* File: BPD220.pex.netlist
* Created: Tue Aug 11 12:45:08 2026
* Program "Calibre xRC"
* Version "v2017.2_16.14"
*
.subckt BPD220 VSS PAD P_EN N_EN VDD TO_CORE
M0 VDD P_EN PAD VDD P L=1.8e-06 W=8.15e-05 AD=3.1785e-10 AS=3.097e-10
+ PD=0.0001708 PS=0.0001706 NRD=0.0239264 NRS=0.0251534
M1 PAD P_EN VDD VDD P L=1.8e-06 W=8.15e-05 AD=3.1785e-10 AS=3.1785e-10
+ PD=0.0001708 PS=0.0001708 NRD=0.0239264 NRS=0.0239264
M2 VDD P_EN PAD VDD P L=1.8e-06 W=8.15e-05 AD=5.738e-10 AS=3.1785e-10
+ PD=0.0001774 PS=0.0001708 NRD=0.0239264 NRS=0.0239264
M3 PAD P_EN VDD VDD P L=1.8e-06 W=5.55e-05 AD=3.7185e-10 AS=5.738e-10
+ PD=0.0001244 PS=0.0001774 NRD=0.0351351 NRS=0.04004
M4 TO_CORE 10 VDD VDD P L=1.5e-06 W=2e-05 AD=7.8e-11 AS=7.4e-11 PD=4.78e-05
+ PS=4.74e-05 NRD=0.0975 NRS=0.0975
M5 TO_CORE 10 VDD VDD P L=1.5e-06 W=2e-05 AD=7.8e-11 AS=7.8e-11 PD=4.78e-05
+ PS=4.78e-05 NRD=0.0975 NRS=0.0975
M6 TO_CORE 10 VDD VDD P L=1.5e-06 W=2e-05 AD=7.4e-11 AS=7.8e-11 PD=4.74e-05
+ PS=4.78e-05 NRD=0.0975 NRS=0.0975
M7 8 3 VDD VDD P L=2.5e-06 W=1.5e-05 AD=5.85e-11 AS=5.55e-11 PD=3.78e-05
+ PS=3.74e-05 NRD=0.13 NRS=0.13
M8 VDD 3 8 VDD P L=2.5e-06 W=1.5e-05 AD=5.85e-11 AS=5.85e-11 PD=3.78e-05
+ PS=3.78e-05 NRD=0.13 NRS=0.13
M9 VDD 3 8 VDD P L=2.5e-06 W=1.5e-05 AD=5.85e-11 AS=5.85e-11 PD=3.78e-05
+ PS=3.78e-05 NRD=0.13 NRS=0.13
M10 VSS 10 8 VDD P L=2.5e-06 W=1.5e-05 AD=5.85e-11 AS=5.85e-11 PD=3.78e-05
+ PS=3.78e-05 NRD=0.13 NRS=0.13
M11 VSS 10 8 VDD P L=2.5e-06 W=1.5e-05 AD=5.85e-11 AS=5.85e-11 PD=3.78e-05
+ PS=3.78e-05 NRD=0.13 NRS=0.13
M12 VSS 10 8 VDD P L=2.5e-06 W=1.5e-05 AD=5.85e-11 AS=5.85e-11 PD=3.78e-05
+ PS=3.78e-05 NRD=0.13 NRS=0.13
M13 VSS 10 8 VDD P L=2.5e-06 W=1.5e-05 AD=5.85e-11 AS=5.85e-11 PD=3.78e-05
+ PS=3.78e-05 NRD=0.13 NRS=0.13
M14 VSS 10 8 VDD P L=2.5e-06 W=1.5e-05 AD=5.85e-11 AS=5.85e-11 PD=3.78e-05
+ PS=3.78e-05 NRD=0.13 NRS=0.13
M15 VSS 10 8 VDD P L=2.5e-06 W=1.5e-05 AD=5.85e-11 AS=8.15e-11 PD=3.78e-05
+ PS=4.84e-05 NRD=0.13 NRS=0.15
M16 10 3 8 VDD P L=2.5e-06 W=2e-05 AD=7.8e-11 AS=8.15e-11 PD=4.78e-05
+ PS=4.84e-05 NRD=0.0975 NRS=0.0975
M17 10 3 8 VDD P L=2.5e-06 W=2e-05 AD=7.8e-11 AS=7.8e-11 PD=4.78e-05 PS=4.78e-05
+ NRD=0.0975 NRS=0.0975
M18 10 3 8 VDD P L=2.5e-06 W=2e-05 AD=7.8e-11 AS=7.8e-11 PD=4.78e-05 PS=4.78e-05
+ NRD=0.0975 NRS=0.0975
M19 10 3 8 VDD P L=2.5e-06 W=2e-05 AD=7.8e-11 AS=7.4e-11 PD=4.78e-05 PS=4.74e-05
+ NRD=0.0975 NRS=0.0975
M20 VSS N_EN PAD VSS N L=1.5e-06 W=6.9e-05 AD=4.761e-10 AS=4.623e-10
+ PD=0.0001518 PS=0.0001514 NRD=0.036166 NRS=0.0282609
M21 PAD N_EN VSS VSS N L=1.5e-06 W=6.9e-05 AD=4.968e-10 AS=4.761e-10
+ PD=0.0001524 PS=0.0001518 NRD=0.0394737 NRS=0.0381423
M22 VSS N_EN PAD VSS N L=1.5e-06 W=6.9e-05 AD=4.761e-10 AS=4.968e-10
+ PD=0.0001518 PS=0.0001524 NRD=0.0381423 NRS=0.0374142
M23 PAD N_EN VSS VSS N L=1.5e-06 W=6.9e-05 AD=4.623e-10 AS=4.761e-10
+ PD=0.0001514 PS=0.0001518 NRD=0.0282609 NRS=0.0381423
M24 VSS 10 TO_CORE VSS N L=1.2e-06 W=1.75e-05 AD=6.825e-11 AS=6.475e-11
+ PD=4.28e-05 PS=4.24e-05 NRD=0.111429 NRS=0.111429
M25 VSS 10 TO_CORE VSS N L=1.2e-06 W=1.75e-05 AD=6.825e-11 AS=6.475e-11
+ PD=4.28e-05 PS=4.24e-05 NRD=0.111429 NRS=0.111429
M26 10 3 7 VSS N L=2e-06 W=2e-05 AD=7.8e-11 AS=7.4e-11 PD=4.78e-05 PS=4.74e-05
+ NRD=0.0975 NRS=0.0975
M27 10 3 7 VSS N L=2e-06 W=2e-05 AD=7.8e-11 AS=8.275e-11 PD=4.78e-05 PS=4.84e-05
+ NRD=0.0975 NRS=0.0975
M28 7 10 VDD VSS N L=2e-06 W=1.75e-05 AD=8.275e-11 AS=6.825e-11 PD=4.84e-05
+ PS=4.28e-05 NRD=0.122857 NRS=0.111429
M29 7 10 VDD VSS N L=2e-06 W=1.75e-05 AD=1.1975e-10 AS=6.825e-11 PD=6.84e-05
+ PS=4.28e-05 NRD=0.122857 NRS=0.111429
M30 VSS 3 7 VSS N L=2e-06 W=3e-05 AD=1.12242e-10 AS=1.1975e-10 PD=6.74e-05
+ PS=6.84e-05 NRD=0.0887037 NRS=0.0704167
*R31 PAD 3 686.333
XR0 PAD 3 RNW W=45u L=14.5u
D32 VSS PAD DNWELLPSUB  AREA=0.207105
D33 PAD VDD DPDIFFNWELL  AREA=0.0104896
D34 3 VDD DPDIFFNWELL  AREA=0.00302336
D35 VSS 3 DNDIFFPSUB  AREA=0.0154093
.ends
*
*
* File: BPD22D.sp
* Created: Wed Apr 29 12:58:26 2026
* Program "Calibre xRC"
* Version "v2017.2_16.14"
*
.subckt BPD22D VSS PAD TO_CORE P_EN N_EN VDD
M0 VDD 3 4 VDD P L=3e-06 W=3.4e-05 AD=1.5935e-10 AS=1.258e-10 PD=8.18e-05
+ PS=7.54e-05 NRD=0.0720588 NRS=0.0573529
M1 TO_CORE 4 VDD VDD P L=1.5e-06 W=3.65e-05 AD=1.4235e-10 AS=1.5935e-10
+ PD=8.08e-05 PS=8.18e-05 NRD=0.0534247 NRS=0.0534247
M2 VDD 4 TO_CORE VDD P L=1.5e-06 W=3.65e-05 AD=1.3505e-10 AS=1.4235e-10
+ PD=8.04e-05 PS=8.08e-05 NRD=0.0534247 NRS=0.0534247
M3 PAD P_EN VDD VDD P L=1.8e-06 W=6.5e-05 AD=2.535e-10 AS=2.405e-10 PD=0.0001378
+ PS=0.0001374 NRD=0.03 NRS=0.03
M4 VDD P_EN PAD VDD P L=1.8e-06 W=6.5e-05 AD=2.535e-10 AS=2.535e-10 PD=0.0001378
+ PS=0.0001378 NRD=0.03 NRS=0.03
M5 PAD P_EN VDD VDD P L=1.8e-06 W=6.5e-05 AD=2.535e-10 AS=2.535e-10 PD=0.0001378
+ PS=0.0001378 NRD=0.03 NRS=0.03
M6 VDD P_EN PAD VDD P L=1.8e-06 W=6.5e-05 AD=2.73e-10 AS=2.535e-10 PD=0.0001384
+ PS=0.0001378 NRD=0.03 NRS=0.03
M7 VSS 3 4 VSS N L=3e-06 W=1.9e-05 AD=1.9515e-10 AS=7.03e-11 PD=0.0001029
+ PS=4.54e-05 NRD=0.128947 NRS=0.102632
M8 TO_CORE 4 VSS VSS N L=1.2e-06 W=4.7e-05 AD=1.739e-10 AS=1.9515e-10
+ PD=0.0001014 PS=0.0001029 NRD=0.0414894 NRS=0.0425532
M9 VSS N_EN PAD VSS N L=1.5e-06 W=6.67e-05 AD=2.6013e-10 AS=2.4679e-10
+ PD=0.0001412 PS=0.0001408 NRD=0.0292354 NRS=0.0292354
M10 PAD N_EN VSS VSS N L=1.5e-06 W=6.67e-05 AD=2.6013e-10 AS=2.6013e-10
+ PD=0.0001412 PS=0.0001412 NRD=0.0292354 NRS=0.0292354
M11 VSS N_EN PAD VSS N L=1.5e-06 W=6.67e-05 AD=2.4679e-10 AS=2.6013e-10
+ PD=0.0001408 PS=0.0001412 NRD=0.0292354 NRS=0.0292354
M12 PAD VDD VSS VSS N L=7e-06 W=2.5e-06 AD=5.00075e-11 AS=1.35e-11 PD=3.06e-05
+ PS=1.5e-05 NRD=0.3 NRS=0.6
R13 PAD 3 686.333
D14 VSS PAD DNWELLPSUB  AREA=0.207105
D15 PAD VDD DPDIFFNWELL  AREA=0.0104896
D16 3 VDD DPDIFFNWELL  AREA=0.00302336
D17 VSS 3 DNDIFFPSUB  AREA=0.0154093
.ends
*
*
* File: BPD22U.sp
* Created: Wed Apr 29 12:58:28 2026
* Program "Calibre xRC"
* Version "v2017.2_16.14"
*
.subckt BPD22U VSS PAD TO_CORE P_EN N_EN VDD
M0 VDD 3 4 VDD P L=3e-06 W=3.4e-05 AD=1.5935e-10 AS=1.258e-10 PD=8.18e-05
+ PS=7.54e-05 NRD=0.0720588 NRS=0.0573529
M1 PAD VSS VDD VDD P L=3e-06 W=2.5e-06 AD=1.22975e-10 AS=1.5375e-11 PD=4.83e-05
+ PS=1.65e-05 NRD=0.3 NRS=0.518182
M2 TO_CORE 4 VDD VDD P L=1.5e-06 W=3.65e-05 AD=1.4235e-10 AS=1.5935e-10
+ PD=8.08e-05 PS=8.18e-05 NRD=0.0534247 NRS=0.0534247
M3 VDD 4 TO_CORE VDD P L=1.5e-06 W=3.65e-05 AD=1.3505e-10 AS=1.4235e-10
+ PD=8.04e-05 PS=8.08e-05 NRD=0.0534247 NRS=0.0534247
M4 PAD P_EN VDD VDD P L=1.8e-06 W=6.5e-05 AD=2.535e-10 AS=2.405e-10 PD=0.0001378
+ PS=0.0001374 NRD=0.03 NRS=0.03
M5 VDD P_EN PAD VDD P L=1.8e-06 W=6.5e-05 AD=2.535e-10 AS=2.535e-10 PD=0.0001378
+ PS=0.0001378 NRD=0.03 NRS=0.03
M6 PAD P_EN VDD VDD P L=1.8e-06 W=6.5e-05 AD=2.535e-10 AS=2.535e-10 PD=0.0001378
+ PS=0.0001378 NRD=0.03 NRS=0.03
M7 VDD P_EN PAD VDD P L=1.8e-06 W=6.5e-05 AD=2.73e-10 AS=2.535e-10 PD=0.0001384
+ PS=0.0001378 NRD=0.03 NRS=0.03
M8 VSS 3 4 VSS N L=3e-06 W=1.5e-05 AD=1.7735e-10 AS=5.55e-11 PD=9.49e-05
+ PS=3.74e-05 NRD=0.163333 NRS=0.13
M9 TO_CORE 4 VSS VSS N L=1.2e-06 W=4.3e-05 AD=1.591e-10 AS=1.7735e-10
+ PD=9.34e-05 PS=9.49e-05 NRD=0.0453488 NRS=0.0465116
M10 VSS N_EN PAD VSS N L=1.5e-06 W=6.67e-05 AD=2.6013e-10 AS=2.4679e-10
+ PD=0.0001412 PS=0.0001408 NRD=0.0292354 NRS=0.0292354
M11 PAD N_EN VSS VSS N L=1.5e-06 W=6.67e-05 AD=2.6013e-10 AS=2.6013e-10
+ PD=0.0001412 PS=0.0001412 NRD=0.0292354 NRS=0.0292354
M12 VSS N_EN PAD VSS N L=1.5e-06 W=6.67e-05 AD=2.4679e-10 AS=2.6013e-10
+ PD=0.0001408 PS=0.0001412 NRD=0.0292354 NRS=0.0292354
R13 PAD 3 686.333
D14 VSS PAD DNWELLPSUB  AREA=0.207105
D15 PAD VDD DPDIFFNWELL  AREA=0.0104896
D16 3 VDD DPDIFFNWELL  AREA=0.00302336
D17 VSS 3 DNDIFFPSUB  AREA=0.0154093
.ends
*
*
* File: BPD240.sp
* Created: Wed Apr 29 12:58:29 2026
* Program "Calibre xRC"
* Version "v2017.2_16.14"
*
.subckt BPD240 VSS PAD TO_CORE P_EN N_EN VDD
M0 VDD 3 4 VDD P L=3e-06 W=3.4e-05 AD=1.5935e-10 AS=1.258e-10 PD=8.18e-05
+ PS=7.54e-05 NRD=0.0720588 NRS=0.0573529
M1 TO_CORE 4 VDD VDD P L=1.5e-06 W=3.65e-05 AD=1.4235e-10 AS=1.5935e-10
+ PD=8.08e-05 PS=8.18e-05 NRD=0.0534247 NRS=0.0534247
M2 VDD 4 TO_CORE VDD P L=1.5e-06 W=3.65e-05 AD=1.3505e-10 AS=1.4235e-10
+ PD=8.04e-05 PS=8.08e-05 NRD=0.0534247 NRS=0.0534247
M3 VDD P_EN PAD VDD P L=1.8e-06 W=6.5e-05 AD=2.535e-10 AS=2.405e-10 PD=0.0001378
+ PS=0.0001374 NRD=0.03 NRS=0.03
M4 PAD P_EN VDD VDD P L=1.8e-06 W=6.5e-05 AD=2.535e-10 AS=2.535e-10 PD=0.0001378
+ PS=0.0001378 NRD=0.03 NRS=0.03
M5 VDD P_EN PAD VDD P L=1.8e-06 W=6.5e-05 AD=2.535e-10 AS=2.535e-10 PD=0.0001378
+ PS=0.0001378 NRD=0.03 NRS=0.03
M6 PAD P_EN VDD VDD P L=1.8e-06 W=6.5e-05 AD=2.735e-10 AS=2.535e-10 PD=0.0001388
+ PS=0.0001378 NRD=0.03 NRS=0.03
M7 VDD P_EN PAD VDD P L=1.8e-06 W=4e-05 AD=1.48e-10 AS=2.735e-10 PD=8.74e-05
+ PS=0.0001388 NRD=0.04875 NRS=0.06125
M8 VSS 3 4 VSS N L=3e-06 W=1.7e-05 AD=1.7835e-10 AS=6.29e-11 PD=9.49e-05
+ PS=4.14e-05 NRD=0.139216 NRS=0.114706
M9 TO_CORE 4 VSS VSS N L=1.2e-06 W=4.3e-05 AD=1.591e-10 AS=1.7835e-10
+ PD=9.34e-05 PS=9.49e-05 NRD=0.0453488 NRS=0.0465116
M10 VSS N_EN PAD VSS N L=1.5e-06 W=6.665e-05 AD=2.59935e-10 AS=2.46605e-10
+ PD=0.0001411 PS=0.0001407 NRD=0.0292573 NRS=0.0292573
M11 PAD N_EN VSS VSS N L=1.5e-06 W=6.665e-05 AD=2.59935e-10 AS=2.59935e-10
+ PD=0.0001411 PS=0.0001411 NRD=0.0292573 NRS=0.0292573
M12 VSS N_EN PAD VSS N L=1.5e-06 W=6.665e-05 AD=3.21705e-10 AS=2.59935e-10
+ PD=0.0001695 PS=0.0001411 NRD=0.0329249 NRS=0.0292573
M13 PAD N_EN VSS VSS N L=1.5e-06 W=7.5e-05 AD=2.72135e-10 AS=3.21705e-10
+ PD=0.000147 PS=0.0001695 NRD=0.0262807 NRS=0.0276358
R14 PAD 3 686.333
D15 VSS PAD DNWELLPSUB  AREA=0.207105
D16 PAD VDD DPDIFFNWELL  AREA=0.0104896
D17 3 VDD DPDIFFNWELL  AREA=0.00302336
D18 VSS 3 DNDIFFPSUB  AREA=0.0154093
.ends
*
*
* File: BPD24D.sp
* Created: Wed Apr 29 12:58:31 2026
* Program "Calibre xRC"
* Version "v2017.2_16.14"
*
.subckt BPD24D VSS PAD TO_CORE P_EN VDD N_EN
M0 VDD 3 4 VDD P L=3e-06 W=3.5e-05 AD=1.5985e-10 AS=1.295e-10 PD=8.18e-05
+ PS=7.74e-05 NRD=0.0688095 NRS=0.0557143
M1 TO_CORE 4 VDD VDD P L=1.5e-06 W=3.65e-05 AD=1.4235e-10 AS=1.5985e-10
+ PD=8.08e-05 PS=8.18e-05 NRD=0.0534247 NRS=0.0534247
M2 VDD 4 TO_CORE VDD P L=1.5e-06 W=3.65e-05 AD=1.3505e-10 AS=1.4235e-10
+ PD=8.04e-05 PS=8.08e-05 NRD=0.0534247 NRS=0.0534247
M3 VDD P_EN PAD VDD P L=1.8e-06 W=6.5e-05 AD=2.535e-10 AS=2.405e-10 PD=0.0001378
+ PS=0.0001374 NRD=0.03 NRS=0.03
M4 PAD P_EN VDD VDD P L=1.8e-06 W=6.5e-05 AD=2.535e-10 AS=2.535e-10 PD=0.0001378
+ PS=0.0001378 NRD=0.03 NRS=0.03
M5 VDD P_EN PAD VDD P L=1.8e-06 W=6.5e-05 AD=2.535e-10 AS=2.535e-10 PD=0.0001378
+ PS=0.0001378 NRD=0.03 NRS=0.03
M6 PAD P_EN VDD VDD P L=1.8e-06 W=6.5e-05 AD=2.735e-10 AS=2.535e-10 PD=0.0001388
+ PS=0.0001378 NRD=0.03 NRS=0.03
M7 VDD P_EN PAD VDD P L=1.8e-06 W=4e-05 AD=1.48e-10 AS=2.735e-10 PD=8.74e-05
+ PS=0.0001388 NRD=0.04875 NRS=0.06125
M8 VSS 3 4 VSS N L=3e-06 W=1.9e-05 AD=1.9515e-10 AS=7.03e-11 PD=0.0001029
+ PS=4.54e-05 NRD=0.128947 NRS=0.102632
M9 TO_CORE 4 VSS VSS N L=1.2e-06 W=4.7e-05 AD=1.739e-10 AS=1.9515e-10
+ PD=0.0001014 PS=0.0001029 NRD=0.0414894 NRS=0.0425532
M10 VSS N_EN PAD VSS N L=1.5e-06 W=6.675e-05 AD=2.60325e-10 AS=2.46975e-10
+ PD=0.0001413 PS=0.0001409 NRD=0.0292135 NRS=0.0292135
M11 PAD N_EN VSS VSS N L=1.5e-06 W=6.675e-05 AD=2.60325e-10 AS=2.60325e-10
+ PD=0.0001413 PS=0.0001413 NRD=0.0292135 NRS=0.0292135
M12 VSS N_EN PAD VSS N L=1.5e-06 W=6.675e-05 AD=3.23515e-10 AS=2.60325e-10
+ PD=0.0001697 PS=0.0001413 NRD=0.0328756 NRS=0.0292135
M13 PAD N_EN VSS VSS N L=1.5e-06 W=7.5e-05 AD=2.77902e-10 AS=3.23515e-10
+ PD=0.0001507 PS=0.0001697 NRD=0.0290667 NRS=0.0276358
M14 VSS VDD PAD VSS N L=7e-06 W=2.5e-06 AD=1.35e-11 AS=2.77902e-10 PD=1.5e-05
+ PS=0.0001507 NRD=0.3 NRS=0.885366
R15 PAD 3 686.333
D16 VSS PAD DNWELLPSUB  AREA=0.207105
D17 PAD VDD DPDIFFNWELL  AREA=0.0104896
D18 3 VDD DPDIFFNWELL  AREA=0.00302336
D19 VSS 3 DNDIFFPSUB  AREA=0.0154093
.ends
*
*
* File: BPD24U.sp
* Created: Wed Apr 29 12:58:33 2026
* Program "Calibre xRC"
* Version "v2017.2_16.14"
*
.subckt BPD24U VSS PAD TO_CORE P_EN N_EN VDD
M0 VDD 3 4 VDD P L=3e-06 W=3.4e-05 AD=1.5935e-10 AS=1.258e-10 PD=8.18e-05
+ PS=7.54e-05 NRD=0.0720588 NRS=0.0573529
M1 PAD VSS VDD VDD P L=3e-06 W=2.5e-06 AD=1.04735e-10 AS=1.5375e-11 PD=4.35e-05
+ PS=1.65e-05 NRD=0.3 NRS=0.518182
M2 TO_CORE 4 VDD VDD P L=1.5e-06 W=3.65e-05 AD=1.4235e-10 AS=1.5935e-10
+ PD=8.08e-05 PS=8.18e-05 NRD=0.0534247 NRS=0.0534247
M3 VDD 4 TO_CORE VDD P L=1.5e-06 W=3.65e-05 AD=1.3505e-10 AS=1.4235e-10
+ PD=8.04e-05 PS=8.08e-05 NRD=0.0534247 NRS=0.0534247
M4 VDD P_EN PAD VDD P L=1.8e-06 W=6.5e-05 AD=2.535e-10 AS=2.405e-10 PD=0.0001378
+ PS=0.0001374 NRD=0.03 NRS=0.03
M5 PAD P_EN VDD VDD P L=1.8e-06 W=6.5e-05 AD=2.535e-10 AS=2.535e-10 PD=0.0001378
+ PS=0.0001378 NRD=0.03 NRS=0.03
M6 VDD P_EN PAD VDD P L=1.8e-06 W=6.5e-05 AD=2.535e-10 AS=2.535e-10 PD=0.0001378
+ PS=0.0001378 NRD=0.03 NRS=0.03
M7 PAD P_EN VDD VDD P L=1.8e-06 W=6.5e-05 AD=2.735e-10 AS=2.535e-10 PD=0.0001388
+ PS=0.0001378 NRD=0.03 NRS=0.03
M8 VDD P_EN PAD VDD P L=1.8e-06 W=4e-05 AD=1.48e-10 AS=2.735e-10 PD=8.74e-05
+ PS=0.0001388 NRD=0.04875 NRS=0.06125
M9 VSS 3 4 VSS N L=3e-06 W=1.5e-05 AD=1.7735e-10 AS=5.55e-11 PD=9.49e-05
+ PS=3.74e-05 NRD=0.163333 NRS=0.13
M10 TO_CORE 4 VSS VSS N L=1.2e-06 W=4.3e-05 AD=1.591e-10 AS=1.7735e-10
+ PD=9.34e-05 PS=9.49e-05 NRD=0.0453488 NRS=0.0465116
M11 VSS N_EN PAD VSS N L=1.5e-06 W=6.665e-05 AD=2.59935e-10 AS=2.46605e-10
+ PD=0.0001411 PS=0.0001407 NRD=0.0292573 NRS=0.0292573
M12 PAD N_EN VSS VSS N L=1.5e-06 W=6.665e-05 AD=2.59935e-10 AS=2.59935e-10
+ PD=0.0001411 PS=0.0001411 NRD=0.0292573 NRS=0.0292573
M13 VSS N_EN PAD VSS N L=1.5e-06 W=6.665e-05 AD=3.21705e-10 AS=2.59935e-10
+ PD=0.0001695 PS=0.0001411 NRD=0.0329249 NRS=0.0292573
M14 PAD N_EN VSS VSS N L=1.5e-06 W=7.5e-05 AD=2.83867e-10 AS=3.21705e-10
+ PD=0.000147 PS=0.0001695 NRD=0.0262807 NRS=0.0276358
R15 PAD 3 686.333
D16 VSS PAD DNWELLPSUB  AREA=0.207105
D17 PAD VDD DPDIFFNWELL  AREA=0.0104896
D18 3 VDD DPDIFFNWELL  AREA=0.00302336
D19 VSS 3 DNDIFFPSUB  AREA=0.0154093
.ends
*
*
* File: BPD320.sp
* Created: Wed Apr 29 12:58:35 2026
* Program "Calibre xRC"
* Version "v2017.2_16.14"
*
.subckt BPD320 VSS PAD P_EN N_EN VDD TO_CORE
M0 VDD P_EN PAD VDD P L=1.8e-06 W=8.7e-05 AD=3.393e-10 AS=3.306e-10 PD=0.0001818
+ PS=0.0001816 NRD=0.0224138 NRS=0.0235632
M1 PAD P_EN VDD VDD P L=1.8e-06 W=8.7e-05 AD=3.393e-10 AS=3.393e-10 PD=0.0001818
+ PS=0.0001818 NRD=0.0224138 NRS=0.0224138
M2 VDD P_EN PAD VDD P L=1.8e-06 W=8.7e-05 AD=3.219e-10 AS=3.393e-10 PD=0.0001814
+ PS=0.0001818 NRD=0.0224138 NRS=0.0224138
M3 TO_CORE 10 VDD VDD P L=1.5e-06 W=2e-05 AD=7.8e-11 AS=7.4e-11 PD=4.78e-05
+ PS=4.74e-05 NRD=0.0975 NRS=0.0975
M4 TO_CORE 10 VDD VDD P L=1.5e-06 W=2e-05 AD=7.8e-11 AS=7.8e-11 PD=4.78e-05
+ PS=4.78e-05 NRD=0.0975 NRS=0.0975
M5 TO_CORE 10 VDD VDD P L=1.5e-06 W=2e-05 AD=7.4e-11 AS=7.8e-11 PD=4.74e-05
+ PS=4.78e-05 NRD=0.0975 NRS=0.0975
M6 8 3 VDD VDD P L=2.5e-06 W=1.5e-05 AD=5.85e-11 AS=5.55e-11 PD=3.78e-05
+ PS=3.74e-05 NRD=0.13 NRS=0.13
M7 VDD 3 8 VDD P L=2.5e-06 W=1.5e-05 AD=5.85e-11 AS=5.85e-11 PD=3.78e-05
+ PS=3.78e-05 NRD=0.13 NRS=0.13
M8 VDD 3 8 VDD P L=2.5e-06 W=1.5e-05 AD=5.85e-11 AS=5.85e-11 PD=3.78e-05
+ PS=3.78e-05 NRD=0.13 NRS=0.13
M9 VSS 10 8 VDD P L=2.5e-06 W=1.5e-05 AD=5.85e-11 AS=5.85e-11 PD=3.78e-05
+ PS=3.78e-05 NRD=0.13 NRS=0.13
M10 VSS 10 8 VDD P L=2.5e-06 W=1.5e-05 AD=5.85e-11 AS=5.85e-11 PD=3.78e-05
+ PS=3.78e-05 NRD=0.13 NRS=0.13
M11 VSS 10 8 VDD P L=2.5e-06 W=1.5e-05 AD=5.85e-11 AS=5.85e-11 PD=3.78e-05
+ PS=3.78e-05 NRD=0.13 NRS=0.13
M12 VSS 10 8 VDD P L=2.5e-06 W=1.5e-05 AD=5.85e-11 AS=5.85e-11 PD=3.78e-05
+ PS=3.78e-05 NRD=0.13 NRS=0.13
M13 VSS 10 8 VDD P L=2.5e-06 W=1.5e-05 AD=5.85e-11 AS=5.85e-11 PD=3.78e-05
+ PS=3.78e-05 NRD=0.13 NRS=0.13
M14 VSS 10 8 VDD P L=2.5e-06 W=1.5e-05 AD=5.85e-11 AS=8.15e-11 PD=3.78e-05
+ PS=4.84e-05 NRD=0.13 NRS=0.15
M15 10 3 8 VDD P L=2.5e-06 W=2e-05 AD=7.8e-11 AS=8.15e-11 PD=4.78e-05
+ PS=4.84e-05 NRD=0.0975 NRS=0.0975
M16 10 3 8 VDD P L=2.5e-06 W=2e-05 AD=7.8e-11 AS=7.8e-11 PD=4.78e-05 PS=4.78e-05
+ NRD=0.0975 NRS=0.0975
M17 10 3 8 VDD P L=2.5e-06 W=2e-05 AD=7.8e-11 AS=7.8e-11 PD=4.78e-05 PS=4.78e-05
+ NRD=0.0975 NRS=0.0975
M18 10 3 8 VDD P L=2.5e-06 W=2e-05 AD=7.8e-11 AS=7.4e-11 PD=4.78e-05 PS=4.74e-05
+ NRD=0.0975 NRS=0.0975
M19 VSS N_EN PAD VSS N L=1.5e-06 W=6.7e-05 AD=4.623e-10 AS=4.489e-10
+ PD=0.0001478 PS=0.0001474 NRD=0.0392809 NRS=0.0291045
M20 PAD N_EN VSS VSS N L=1.5e-06 W=6.7e-05 AD=5.025e-10 AS=4.623e-10 PD=0.000149
+ PS=0.0001478 NRD=0.040652 NRS=0.0392809
M21 VSS N_EN PAD VSS N L=1.5e-06 W=6.7e-05 AD=2.479e-10 AS=5.025e-10
+ PD=0.0001414 PS=0.000149 NRD=0.0291045 NRS=0.040652
M22 VSS 10 TO_CORE VSS N L=1.2e-06 W=1.75e-05 AD=6.825e-11 AS=6.475e-11
+ PD=4.28e-05 PS=4.24e-05 NRD=0.111429 NRS=0.111429
M23 VSS 10 TO_CORE VSS N L=1.2e-06 W=1.75e-05 AD=6.825e-11 AS=6.475e-11
+ PD=4.28e-05 PS=4.24e-05 NRD=0.111429 NRS=0.111429
M24 10 3 7 VSS N L=2e-06 W=2e-05 AD=7.8e-11 AS=7.4e-11 PD=4.78e-05 PS=4.74e-05
+ NRD=0.0975 NRS=0.0975
M25 10 3 7 VSS N L=2e-06 W=2e-05 AD=7.8e-11 AS=8.275e-11 PD=4.78e-05 PS=4.84e-05
+ NRD=0.0975 NRS=0.0975
M26 7 10 VDD VSS N L=2e-06 W=1.75e-05 AD=8.275e-11 AS=6.825e-11 PD=4.84e-05
+ PS=4.28e-05 NRD=0.122857 NRS=0.111429
M27 7 10 VDD VSS N L=2e-06 W=1.75e-05 AD=1.1975e-10 AS=6.825e-11 PD=6.84e-05
+ PS=4.28e-05 NRD=0.122857 NRS=0.111429
M28 VSS 3 7 VSS N L=2e-06 W=3e-05 AD=1.12242e-10 AS=1.1975e-10 PD=6.74e-05
+ PS=6.84e-05 NRD=0.0887037 NRS=0.0704167
R29 PAD 3 686.333
D30 VSS PAD DNWELLPSUB  AREA=0.207105
D31 PAD VDD DPDIFFNWELL  AREA=0.0104896
D32 3 VDD DPDIFFNWELL  AREA=0.00302336
D33 VSS 3 DNDIFFPSUB  AREA=0.0154093
.ends
*
*
* File: BPD340.sp
* Created: Wed Apr 29 12:58:37 2026
* Program "Calibre xRC"
* Version "v2017.2_16.14"
*
.subckt BPD340 VSS PAD P_EN N_EN VDD TO_CORE
M0 VDD P_EN PAD VDD P L=1.8e-06 W=8.15e-05 AD=3.1785e-10 AS=3.097e-10
+ PD=0.0001708 PS=0.0001706 NRD=0.0239264 NRS=0.0251534
M1 PAD P_EN VDD VDD P L=1.8e-06 W=8.15e-05 AD=3.1785e-10 AS=3.1785e-10
+ PD=0.0001708 PS=0.0001708 NRD=0.0239264 NRS=0.0239264
M2 VDD P_EN PAD VDD P L=1.8e-06 W=8.15e-05 AD=5.738e-10 AS=3.1785e-10
+ PD=0.0001774 PS=0.0001708 NRD=0.0239264 NRS=0.0239264
M3 PAD P_EN VDD VDD P L=1.8e-06 W=5.55e-05 AD=3.7185e-10 AS=5.738e-10
+ PD=0.0001244 PS=0.0001774 NRD=0.0351351 NRS=0.04004
M4 TO_CORE 10 VDD VDD P L=1.5e-06 W=2e-05 AD=7.8e-11 AS=7.4e-11 PD=4.78e-05
+ PS=4.74e-05 NRD=0.0975 NRS=0.0975
M5 TO_CORE 10 VDD VDD P L=1.5e-06 W=2e-05 AD=7.8e-11 AS=7.8e-11 PD=4.78e-05
+ PS=4.78e-05 NRD=0.0975 NRS=0.0975
M6 TO_CORE 10 VDD VDD P L=1.5e-06 W=2e-05 AD=7.4e-11 AS=7.8e-11 PD=4.74e-05
+ PS=4.78e-05 NRD=0.0975 NRS=0.0975
M7 8 3 VDD VDD P L=2.5e-06 W=1.5e-05 AD=5.85e-11 AS=5.55e-11 PD=3.78e-05
+ PS=3.74e-05 NRD=0.13 NRS=0.13
M8 VDD 3 8 VDD P L=2.5e-06 W=1.5e-05 AD=5.85e-11 AS=5.85e-11 PD=3.78e-05
+ PS=3.78e-05 NRD=0.13 NRS=0.13
M9 VDD 3 8 VDD P L=2.5e-06 W=1.5e-05 AD=5.85e-11 AS=5.85e-11 PD=3.78e-05
+ PS=3.78e-05 NRD=0.13 NRS=0.13
M10 VSS 10 8 VDD P L=2.5e-06 W=1.5e-05 AD=5.85e-11 AS=5.85e-11 PD=3.78e-05
+ PS=3.78e-05 NRD=0.13 NRS=0.13
M11 VSS 10 8 VDD P L=2.5e-06 W=1.5e-05 AD=5.85e-11 AS=5.85e-11 PD=3.78e-05
+ PS=3.78e-05 NRD=0.13 NRS=0.13
M12 VSS 10 8 VDD P L=2.5e-06 W=1.5e-05 AD=5.85e-11 AS=5.85e-11 PD=3.78e-05
+ PS=3.78e-05 NRD=0.13 NRS=0.13
M13 VSS 10 8 VDD P L=2.5e-06 W=1.5e-05 AD=5.85e-11 AS=5.85e-11 PD=3.78e-05
+ PS=3.78e-05 NRD=0.13 NRS=0.13
M14 VSS 10 8 VDD P L=2.5e-06 W=1.5e-05 AD=5.85e-11 AS=5.85e-11 PD=3.78e-05
+ PS=3.78e-05 NRD=0.13 NRS=0.13
M15 VSS 10 8 VDD P L=2.5e-06 W=1.5e-05 AD=5.85e-11 AS=8.15e-11 PD=3.78e-05
+ PS=4.84e-05 NRD=0.13 NRS=0.15
M16 10 3 8 VDD P L=2.5e-06 W=2e-05 AD=7.8e-11 AS=8.15e-11 PD=4.78e-05
+ PS=4.84e-05 NRD=0.0975 NRS=0.0975
M17 10 3 8 VDD P L=2.5e-06 W=2e-05 AD=7.8e-11 AS=7.8e-11 PD=4.78e-05 PS=4.78e-05
+ NRD=0.0975 NRS=0.0975
M18 10 3 8 VDD P L=2.5e-06 W=2e-05 AD=7.8e-11 AS=7.8e-11 PD=4.78e-05 PS=4.78e-05
+ NRD=0.0975 NRS=0.0975
M19 10 3 8 VDD P L=2.5e-06 W=2e-05 AD=7.8e-11 AS=7.4e-11 PD=4.78e-05 PS=4.74e-05
+ NRD=0.0975 NRS=0.0975
M20 VSS N_EN PAD VSS N L=1.5e-06 W=6.9e-05 AD=4.761e-10 AS=4.623e-10
+ PD=0.0001518 PS=0.0001514 NRD=0.036166 NRS=0.0282609
M21 PAD N_EN VSS VSS N L=1.5e-06 W=6.9e-05 AD=4.968e-10 AS=4.761e-10
+ PD=0.0001524 PS=0.0001518 NRD=0.0394737 NRS=0.0381423
M22 VSS N_EN PAD VSS N L=1.5e-06 W=6.9e-05 AD=4.761e-10 AS=4.968e-10
+ PD=0.0001518 PS=0.0001524 NRD=0.0381423 NRS=0.0374142
M23 PAD N_EN VSS VSS N L=1.5e-06 W=6.9e-05 AD=4.623e-10 AS=4.761e-10
+ PD=0.0001514 PS=0.0001518 NRD=0.0282609 NRS=0.0381423
M24 VSS 10 TO_CORE VSS N L=1.2e-06 W=1.75e-05 AD=6.825e-11 AS=6.475e-11
+ PD=4.28e-05 PS=4.24e-05 NRD=0.111429 NRS=0.111429
M25 VSS 10 TO_CORE VSS N L=1.2e-06 W=1.75e-05 AD=6.825e-11 AS=6.475e-11
+ PD=4.28e-05 PS=4.24e-05 NRD=0.111429 NRS=0.111429
M26 10 3 7 VSS N L=2e-06 W=2e-05 AD=7.8e-11 AS=7.4e-11 PD=4.78e-05 PS=4.74e-05
+ NRD=0.0975 NRS=0.0975
M27 10 3 7 VSS N L=2e-06 W=2e-05 AD=7.8e-11 AS=8.275e-11 PD=4.78e-05 PS=4.84e-05
+ NRD=0.0975 NRS=0.0975
M28 7 10 VDD VSS N L=2e-06 W=1.75e-05 AD=8.275e-11 AS=6.825e-11 PD=4.84e-05
+ PS=4.28e-05 NRD=0.122857 NRS=0.111429
M29 7 10 VDD VSS N L=2e-06 W=1.75e-05 AD=1.1975e-10 AS=6.825e-11 PD=6.84e-05
+ PS=4.28e-05 NRD=0.122857 NRS=0.111429
M30 VSS 3 7 VSS N L=2e-06 W=3e-05 AD=1.12242e-10 AS=1.1975e-10 PD=6.74e-05
+ PS=6.84e-05 NRD=0.0887037 NRS=0.0704167
R31 PAD 3 686.333
D32 VSS PAD DNWELLPSUB  AREA=0.207105
D33 PAD VDD DPDIFFNWELL  AREA=0.0104896
D34 3 VDD DPDIFFNWELL  AREA=0.00302336
D35 VSS 3 DNDIFFPSUB  AREA=0.0154093
.ends
*
*

* File: IPAD20.sp
* Created: Mon Apr 27 16:24:37 2026
* Program "Calibre xRC"
* Version "v2017.2_16.14"
*
.subckt IPAD20 VSS IN1 OUT1 VDD
M0 VDD 3 4 VDD P L=3e-06 W=3.4e-05 AD=1.5935e-10 AS=1.258e-10 PD=8.18e-05
+ PS=7.54e-05 NRD=0.0720588 NRS=0.0573529
M1 OUT1 4 VDD VDD P L=1.5e-06 W=3.65e-05 AD=1.4235e-10 AS=1.5935e-10 PD=8.08e-05
+ PS=8.18e-05 NRD=0.0534247 NRS=0.0534247
M2 VDD 4 OUT1 VDD P L=1.5e-06 W=3.65e-05 AD=1.3505e-10 AS=1.4235e-10 PD=8.04e-05
+ PS=8.08e-05 NRD=0.0534247 NRS=0.0534247
M3 VSS 3 4 VSS N L=3e-06 W=1.7e-05 AD=1.7835e-10 AS=6.29e-11 PD=9.49e-05
+ PS=4.14e-05 NRD=0.139216 NRS=0.114706
M4 OUT1 4 VSS VSS N L=1.2e-06 W=4.3e-05 AD=1.591e-10 AS=1.7835e-10 PD=9.34e-05
+ PS=9.49e-05 NRD=0.0453488 NRS=0.0465116
*R5 IN1 3 686.333
XR0 IN1 3 RNW W=45u L=14.5u
D6 VSS IN1 DNWELLPSUB  AREA=0.207105
D7 IN1 VDD DPDIFFNWELL  AREA=0.0104896
D8 3 VDD DPDIFFNWELL  AREA=0.00302336
D9 VSS 3 DNDIFFPSUB  AREA=0.0154093
.ends
*
*
* File: IPAD2D.sp
* Created: Wed Apr 29 12:58:11 2026
* Program "Calibre xRC"
* Version "v2017.2_16.14"
*
.subckt IPAD2D VSS IN1 VDD OUT1
M0 VDD 3 5 VDD P L=3e-06 W=3.5e-05 AD=1.5985e-10 AS=1.295e-10 PD=8.18e-05
+ PS=7.74e-05 NRD=0.0688095 NRS=0.0557143
M1 OUT1 5 VDD VDD P L=1.5e-06 W=3.65e-05 AD=1.4235e-10 AS=1.5985e-10 PD=8.08e-05
+ PS=8.18e-05 NRD=0.0534247 NRS=0.0534247
M2 VDD 5 OUT1 VDD P L=1.5e-06 W=3.65e-05 AD=1.3505e-10 AS=1.4235e-10 PD=8.04e-05
+ PS=8.08e-05 NRD=0.0534247 NRS=0.0534247
M3 VSS 3 5 VSS N L=3e-06 W=1.9e-05 AD=1.9515e-10 AS=7.03e-11 PD=0.0001029
+ PS=4.54e-05 NRD=0.125188 NRS=0.102632
M4 VSS VDD IN1 VSS N L=7e-06 W=2.5e-06 AD=1.35e-11 AS=1.10525e-10 PD=1.5e-05
+ PS=4.61e-05 NRD=0.7 NRS=1.14706
M5 OUT1 5 VSS VSS N L=1.2e-06 W=4.7e-05 AD=1.739e-10 AS=1.9515e-10 PD=0.0001014
+ PS=0.0001029 NRD=0.0414894 NRS=0.0425532
R6 IN1 3 686.333
D7 VSS IN1 DNWELLPSUB  AREA=0.207105
D8 IN1 VDD DPDIFFNWELL  AREA=0.0104896
D9 3 VDD DPDIFFNWELL  AREA=0.00302336
D10 VSS 3 DNDIFFPSUB  AREA=0.0154093
.ends
*
*
* File: IPAD2U.sp
* Created: Wed Apr 29 12:58:13 2026
* Program "Calibre xRC"
* Version "v2017.2_16.14"
*
.subckt IPAD2U VSS IN1 OUT1 VDD
M0 VDD 3 4 VDD P L=3e-06 W=3.4e-05 AD=1.5935e-10 AS=1.258e-10 PD=8.18e-05
+ PS=7.54e-05 NRD=0.0720588 NRS=0.0573529
M1 IN1 VSS VDD VDD P L=3e-06 W=2.5e-06 AD=1.2244e-10 AS=1.5375e-11 PD=4.93e-05
+ PS=1.65e-05 NRD=0.3 NRS=0.518182
M2 OUT1 4 VDD VDD P L=1.5e-06 W=3.65e-05 AD=1.4235e-10 AS=1.5935e-10 PD=8.08e-05
+ PS=8.18e-05 NRD=0.0534247 NRS=0.0534247
M3 VDD 4 OUT1 VDD P L=1.5e-06 W=3.65e-05 AD=1.3505e-10 AS=1.4235e-10 PD=8.04e-05
+ PS=8.08e-05 NRD=0.0534247 NRS=0.0534247
M4 VSS 3 4 VSS N L=3e-06 W=1.5e-05 AD=1.7735e-10 AS=5.55e-11 PD=9.49e-05
+ PS=3.74e-05 NRD=0.163333 NRS=0.13
M5 OUT1 4 VSS VSS N L=1.2e-06 W=4.3e-05 AD=1.591e-10 AS=1.7735e-10 PD=9.34e-05
+ PS=9.49e-05 NRD=0.0453488 NRS=0.0465116
R6 IN1 3 686.333
D7 VSS IN1 DNWELLPSUB  AREA=0.207105
D8 IN1 VDD DPDIFFNWELL  AREA=0.0104896
D9 3 VDD DPDIFFNWELL  AREA=0.00302336
D10 VSS 3 DNDIFFPSUB  AREA=0.0154093
.ends
*
*
* File: IPAD30.sp
* Created: Wed Apr 29 12:58:14 2026
* Program "Calibre xRC"
* Version "v2017.2_16.14"
*
.subckt IPAD30 VSS IN1 VDD OUT1
M0 OUT1 8 VDD VDD P L=1.5e-06 W=2e-05 AD=7.8e-11 AS=7.4e-11 PD=4.78e-05
+ PS=4.74e-05 NRD=0.0975 NRS=0.0975
M1 OUT1 8 VDD VDD P L=1.5e-06 W=2e-05 AD=7.8e-11 AS=7.8e-11 PD=4.78e-05
+ PS=4.78e-05 NRD=0.0975 NRS=0.0975
M2 OUT1 8 VDD VDD P L=1.5e-06 W=2e-05 AD=7.4e-11 AS=7.8e-11 PD=4.74e-05
+ PS=4.78e-05 NRD=0.0975 NRS=0.0975
M3 6 3 VDD VDD P L=2.5e-06 W=1.5e-05 AD=5.85e-11 AS=5.55e-11 PD=3.78e-05
+ PS=3.74e-05 NRD=0.13 NRS=0.13
M4 VDD 3 6 VDD P L=2.5e-06 W=1.5e-05 AD=5.85e-11 AS=5.85e-11 PD=3.78e-05
+ PS=3.78e-05 NRD=0.13 NRS=0.13
M5 VDD 3 6 VDD P L=2.5e-06 W=1.5e-05 AD=5.85e-11 AS=5.85e-11 PD=3.78e-05
+ PS=3.78e-05 NRD=0.13 NRS=0.13
M6 VSS 8 6 VDD P L=2.5e-06 W=1.5e-05 AD=5.85e-11 AS=5.85e-11 PD=3.78e-05
+ PS=3.78e-05 NRD=0.13 NRS=0.13
M7 VSS 8 6 VDD P L=2.5e-06 W=1.5e-05 AD=5.85e-11 AS=5.85e-11 PD=3.78e-05
+ PS=3.78e-05 NRD=0.13 NRS=0.13
M8 VSS 8 6 VDD P L=2.5e-06 W=1.5e-05 AD=5.85e-11 AS=5.85e-11 PD=3.78e-05
+ PS=3.78e-05 NRD=0.13 NRS=0.13
M9 VSS 8 6 VDD P L=2.5e-06 W=1.5e-05 AD=5.85e-11 AS=5.85e-11 PD=3.78e-05
+ PS=3.78e-05 NRD=0.13 NRS=0.13
M10 VSS 8 6 VDD P L=2.5e-06 W=1.5e-05 AD=5.85e-11 AS=5.85e-11 PD=3.78e-05
+ PS=3.78e-05 NRD=0.13 NRS=0.13
M11 VSS 8 6 VDD P L=2.5e-06 W=1.5e-05 AD=5.85e-11 AS=8.15e-11 PD=3.78e-05
+ PS=4.84e-05 NRD=0.13 NRS=0.15
M12 8 3 6 VDD P L=2.5e-06 W=2e-05 AD=7.8e-11 AS=8.15e-11 PD=4.78e-05 PS=4.84e-05
+ NRD=0.0975 NRS=0.0975
M13 8 3 6 VDD P L=2.5e-06 W=2e-05 AD=7.8e-11 AS=7.8e-11 PD=4.78e-05 PS=4.78e-05
+ NRD=0.0975 NRS=0.0975
M14 8 3 6 VDD P L=2.5e-06 W=2e-05 AD=7.8e-11 AS=7.8e-11 PD=4.78e-05 PS=4.78e-05
+ NRD=0.0975 NRS=0.0975
M15 8 3 6 VDD P L=2.5e-06 W=2e-05 AD=7.8e-11 AS=7.4e-11 PD=4.78e-05 PS=4.74e-05
+ NRD=0.0975 NRS=0.0975
M16 VSS 8 OUT1 VSS N L=1.2e-06 W=1.75e-05 AD=6.825e-11 AS=6.475e-11 PD=4.28e-05
+ PS=4.24e-05 NRD=0.111429 NRS=0.111429
M17 VSS 8 OUT1 VSS N L=1.2e-06 W=1.75e-05 AD=6.825e-11 AS=6.475e-11 PD=4.28e-05
+ PS=4.24e-05 NRD=0.111429 NRS=0.111429
M18 8 3 5 VSS N L=2e-06 W=2e-05 AD=7.8e-11 AS=7.4e-11 PD=4.78e-05 PS=4.74e-05
+ NRD=0.0975 NRS=0.0975
M19 8 3 5 VSS N L=2e-06 W=2e-05 AD=7.8e-11 AS=8.275e-11 PD=4.78e-05 PS=4.84e-05
+ NRD=0.0975 NRS=0.0975
M20 5 8 VDD VSS N L=2e-06 W=1.75e-05 AD=8.275e-11 AS=6.825e-11 PD=4.84e-05
+ PS=4.28e-05 NRD=0.122857 NRS=0.111429
M21 5 8 VDD VSS N L=2e-06 W=1.75e-05 AD=1.234e-10 AS=6.825e-11 PD=6.94e-05
+ PS=4.28e-05 NRD=0.128571 NRS=0.111429
M22 5 3 VSS VSS N L=2e-06 W=3e-05 AD=1.234e-10 AS=1.24715e-10 PD=6.94e-05
+ PS=6.05e-05 NRD=0.0862963 NRS=0.0737226
R23 IN1 3 686.333
D24 VSS IN1 DNWELLPSUB  AREA=0.207105
D25 IN1 VDD DPDIFFNWELL  AREA=0.0104896
D26 3 VDD DPDIFFNWELL  AREA=0.00302336
D27 VSS 3 DNDIFFPSUB  AREA=0.0154093
.ends
*
*
* File: IPAD3D.sp
* Created: Wed Apr 29 12:58:16 2026
* Program "Calibre xRC"
* Version "v2017.2_16.14"
*
.subckt IPAD3D VSS IN1 VDD OUT1
M0 OUT1 8 VDD VDD P L=1.5e-06 W=2e-05 AD=7.8e-11 AS=7.4e-11 PD=4.78e-05
+ PS=4.74e-05 NRD=0.0975 NRS=0.0975
M1 OUT1 8 VDD VDD P L=1.5e-06 W=2e-05 AD=7.8e-11 AS=7.8e-11 PD=4.78e-05
+ PS=4.78e-05 NRD=0.0975 NRS=0.0975
M2 OUT1 8 VDD VDD P L=1.5e-06 W=2e-05 AD=7.4e-11 AS=7.8e-11 PD=4.74e-05
+ PS=4.78e-05 NRD=0.0975 NRS=0.0975
M3 6 3 VDD VDD P L=2.5e-06 W=1.5e-05 AD=5.85e-11 AS=5.55e-11 PD=3.78e-05
+ PS=3.74e-05 NRD=0.13 NRS=0.13
M4 VDD 3 6 VDD P L=2.5e-06 W=1.5e-05 AD=5.85e-11 AS=5.85e-11 PD=3.78e-05
+ PS=3.78e-05 NRD=0.13 NRS=0.13
M5 VDD 3 6 VDD P L=2.5e-06 W=1.5e-05 AD=5.85e-11 AS=5.85e-11 PD=3.78e-05
+ PS=3.78e-05 NRD=0.13 NRS=0.13
M6 VSS 8 6 VDD P L=2.5e-06 W=1.5e-05 AD=5.85e-11 AS=5.85e-11 PD=3.78e-05
+ PS=3.78e-05 NRD=0.13 NRS=0.13
M7 VSS 8 6 VDD P L=2.5e-06 W=1.5e-05 AD=5.85e-11 AS=5.85e-11 PD=3.78e-05
+ PS=3.78e-05 NRD=0.13 NRS=0.13
M8 VSS 8 6 VDD P L=2.5e-06 W=1.5e-05 AD=5.85e-11 AS=5.85e-11 PD=3.78e-05
+ PS=3.78e-05 NRD=0.13 NRS=0.13
M9 VSS 8 6 VDD P L=2.5e-06 W=1.5e-05 AD=5.85e-11 AS=5.85e-11 PD=3.78e-05
+ PS=3.78e-05 NRD=0.13 NRS=0.13
M10 VSS 8 6 VDD P L=2.5e-06 W=1.5e-05 AD=5.85e-11 AS=5.85e-11 PD=3.78e-05
+ PS=3.78e-05 NRD=0.13 NRS=0.13
M11 VSS 8 6 VDD P L=2.5e-06 W=1.5e-05 AD=5.85e-11 AS=8.15e-11 PD=3.78e-05
+ PS=4.84e-05 NRD=0.13 NRS=0.15
M12 8 3 6 VDD P L=2.5e-06 W=2e-05 AD=7.8e-11 AS=8.15e-11 PD=4.78e-05 PS=4.84e-05
+ NRD=0.0975 NRS=0.0975
M13 8 3 6 VDD P L=2.5e-06 W=2e-05 AD=7.8e-11 AS=7.8e-11 PD=4.78e-05 PS=4.78e-05
+ NRD=0.0975 NRS=0.0975
M14 8 3 6 VDD P L=2.5e-06 W=2e-05 AD=7.8e-11 AS=7.8e-11 PD=4.78e-05 PS=4.78e-05
+ NRD=0.0975 NRS=0.0975
M15 8 3 6 VDD P L=2.5e-06 W=2e-05 AD=7.8e-11 AS=7.4e-11 PD=4.78e-05 PS=4.74e-05
+ NRD=0.0975 NRS=0.0975
M16 IN1 VDD VSS VSS N L=7e-06 W=2.5e-06 AD=3.4325e-11 AS=1.8645e-11 PD=2.43e-05
+ PS=1.79e-05 NRD=0.9 NRS=0.9
M17 VSS 8 OUT1 VSS N L=1.2e-06 W=1.75e-05 AD=6.825e-11 AS=6.475e-11 PD=4.28e-05
+ PS=4.24e-05 NRD=0.111429 NRS=0.111429
M18 VSS 8 OUT1 VSS N L=1.2e-06 W=1.75e-05 AD=6.825e-11 AS=6.475e-11 PD=4.28e-05
+ PS=4.24e-05 NRD=0.111429 NRS=0.111429
M19 8 3 5 VSS N L=2e-06 W=2e-05 AD=7.8e-11 AS=7.4e-11 PD=4.78e-05 PS=4.74e-05
+ NRD=0.0975 NRS=0.0975
M20 8 3 5 VSS N L=2e-06 W=2e-05 AD=7.8e-11 AS=8.275e-11 PD=4.78e-05 PS=4.84e-05
+ NRD=0.0975 NRS=0.0975
M21 5 8 VDD VSS N L=2e-06 W=1.75e-05 AD=8.275e-11 AS=6.825e-11 PD=4.84e-05
+ PS=4.28e-05 NRD=0.122857 NRS=0.111429
M22 5 8 VDD VSS N L=2e-06 W=1.75e-05 AD=1.234e-10 AS=6.825e-11 PD=6.94e-05
+ PS=4.28e-05 NRD=0.128571 NRS=0.111429
M23 5 3 VSS VSS N L=2e-06 W=3e-05 AD=1.234e-10 AS=1.24715e-10 PD=6.94e-05
+ PS=6.05e-05 NRD=0.0862963 NRS=0.0737226
R24 IN1 3 686.333
D25 VSS IN1 DNWELLPSUB  AREA=0.207105
D26 IN1 VDD DPDIFFNWELL  AREA=0.0104896
D27 3 VDD DPDIFFNWELL  AREA=0.00302336
D28 VSS 3 DNDIFFPSUB  AREA=0.0154093
.ends
*
*
* File: IPAD3U.sp
* Created: Wed Apr 29 12:58:18 2026
* Program "Calibre xRC"
* Version "v2017.2_16.14"
*
.subckt IPAD3U VSS IN1 VDD OUT1
M0 OUT1 8 VDD VDD P L=1.5e-06 W=2e-05 AD=7.8e-11 AS=7.4e-11 PD=4.78e-05
+ PS=4.74e-05 NRD=0.0975 NRS=0.0975
M1 OUT1 8 VDD VDD P L=1.5e-06 W=2e-05 AD=7.8e-11 AS=7.8e-11 PD=4.78e-05
+ PS=4.78e-05 NRD=0.0975 NRS=0.0975
M2 OUT1 8 VDD VDD P L=1.5e-06 W=2e-05 AD=7.4e-11 AS=7.8e-11 PD=4.74e-05
+ PS=4.78e-05 NRD=0.0975 NRS=0.0975
M3 6 3 VDD VDD P L=2.5e-06 W=1.5e-05 AD=5.85e-11 AS=5.55e-11 PD=3.78e-05
+ PS=3.74e-05 NRD=0.13 NRS=0.13
M4 VDD 3 6 VDD P L=2.5e-06 W=1.5e-05 AD=5.85e-11 AS=5.85e-11 PD=3.78e-05
+ PS=3.78e-05 NRD=0.13 NRS=0.13
M5 VDD 3 6 VDD P L=2.5e-06 W=1.5e-05 AD=5.85e-11 AS=5.85e-11 PD=3.78e-05
+ PS=3.78e-05 NRD=0.13 NRS=0.13
M6 VSS 8 6 VDD P L=2.5e-06 W=1.5e-05 AD=5.85e-11 AS=5.85e-11 PD=3.78e-05
+ PS=3.78e-05 NRD=0.13 NRS=0.13
M7 VSS 8 6 VDD P L=2.5e-06 W=1.5e-05 AD=5.85e-11 AS=5.85e-11 PD=3.78e-05
+ PS=3.78e-05 NRD=0.13 NRS=0.13
M8 VSS 8 6 VDD P L=2.5e-06 W=1.5e-05 AD=5.85e-11 AS=5.85e-11 PD=3.78e-05
+ PS=3.78e-05 NRD=0.13 NRS=0.13
M9 VSS 8 6 VDD P L=2.5e-06 W=1.5e-05 AD=5.85e-11 AS=5.85e-11 PD=3.78e-05
+ PS=3.78e-05 NRD=0.13 NRS=0.13
M10 VSS 8 6 VDD P L=2.5e-06 W=1.5e-05 AD=5.85e-11 AS=5.85e-11 PD=3.78e-05
+ PS=3.78e-05 NRD=0.13 NRS=0.13
M11 VSS 8 6 VDD P L=2.5e-06 W=1.5e-05 AD=5.85e-11 AS=8.15e-11 PD=3.78e-05
+ PS=4.84e-05 NRD=0.13 NRS=0.15
M12 8 3 6 VDD P L=2.5e-06 W=2e-05 AD=7.8e-11 AS=8.15e-11 PD=4.78e-05 PS=4.84e-05
+ NRD=0.0975 NRS=0.0975
M13 8 3 6 VDD P L=2.5e-06 W=2e-05 AD=7.8e-11 AS=7.8e-11 PD=4.78e-05 PS=4.78e-05
+ NRD=0.0975 NRS=0.0975
M14 8 3 6 VDD P L=2.5e-06 W=2e-05 AD=7.8e-11 AS=7.8e-11 PD=4.78e-05 PS=4.78e-05
+ NRD=0.0975 NRS=0.0975
M15 8 3 6 VDD P L=2.5e-06 W=2e-05 AD=7.8e-11 AS=7.4e-11 PD=4.78e-05 PS=4.74e-05
+ NRD=0.0975 NRS=0.0975
M16 IN1 VSS VDD VDD P L=3e-06 W=2.5e-06 AD=2.4175e-11 AS=2.4805e-11 PD=2.11e-05
+ PS=2.14e-05 NRD=0.3 NRS=0.592683
M17 VSS 8 OUT1 VSS N L=1.2e-06 W=1.75e-05 AD=6.825e-11 AS=6.475e-11 PD=4.28e-05
+ PS=4.24e-05 NRD=0.111429 NRS=0.111429
M18 VSS 8 OUT1 VSS N L=1.2e-06 W=1.75e-05 AD=6.825e-11 AS=6.475e-11 PD=4.28e-05
+ PS=4.24e-05 NRD=0.111429 NRS=0.111429
M19 8 3 5 VSS N L=2e-06 W=2e-05 AD=7.8e-11 AS=7.4e-11 PD=4.78e-05 PS=4.74e-05
+ NRD=0.0975 NRS=0.0975
M20 8 3 5 VSS N L=2e-06 W=2e-05 AD=7.8e-11 AS=8.275e-11 PD=4.78e-05 PS=4.84e-05
+ NRD=0.0975 NRS=0.0975
M21 5 8 VDD VSS N L=2e-06 W=1.75e-05 AD=8.275e-11 AS=6.825e-11 PD=4.84e-05
+ PS=4.28e-05 NRD=0.122857 NRS=0.111429
M22 5 8 VDD VSS N L=2e-06 W=1.75e-05 AD=1.234e-10 AS=6.825e-11 PD=6.94e-05
+ PS=4.28e-05 NRD=0.128571 NRS=0.111429
M23 5 3 VSS VSS N L=2e-06 W=3e-05 AD=1.234e-10 AS=1.24715e-10 PD=6.94e-05
+ PS=6.05e-05 NRD=0.0862963 NRS=0.0737226
R24 IN1 3 686.333
D25 VSS IN1 DNWELLPSUB  AREA=0.207105
D26 IN1 VDD DPDIFFNWELL  AREA=0.0104896
D27 3 VDD DPDIFFNWELL  AREA=0.00302336
D28 VSS 3 DNDIFFPSUB  AREA=0.0154093
.ends
*
*
* File: OPAD02.sp
* Created: Mon Apr 27 16:25:09 2026
* Program "Calibre xRC"
* Version "v2017.2_16.14"
*
.subckt OPAD02 VSS PAD IN1 VDD
M0 VDD IN1 PAD VDD P L=1.8e-06 W=8.7e-05 AD=6.003e-10 AS=5.916e-10 PD=0.0001878
+ PS=0.0001876 NRD=0.0706897 NRS=0.0165517
M1 PAD IN1 VDD VDD P L=1.8e-06 W=8.7e-05 AD=6.003e-10 AS=6.003e-10 PD=0.0001878
+ PS=0.0001878 NRD=0.033908 NRS=0.0224138
M2 VDD IN1 PAD VDD P L=1.8e-06 W=8.7e-05 AD=3.219e-10 AS=6.003e-10 PD=0.0001814
+ PS=0.0001878 NRD=0.0637931 NRS=0.0162069
M3 VSS IN1 PAD VSS N L=1.5e-06 W=6.35e-05 AD=4.3815e-10 AS=4.2545e-10
+ PD=0.0001408 PS=0.0001404 NRD=0.0769029 NRS=0.0222047
M4 PAD IN1 VSS VSS N L=1.5e-06 W=6.35e-05 AD=4.7625e-10 AS=4.3815e-10
+ PD=0.000142 PS=0.0001408 NRD=0.0496063 NRS=0.0419573
M5 VSS IN1 PAD VSS N L=1.5e-06 W=6.35e-05 AD=2.3495e-10 AS=4.7625e-10
+ PD=0.0001344 PS=0.000142 NRD=0.106299 NRS=0.0240945
D6 VSS PAD DNWELLPSUB  AREA=0.196343
.ends
*
*
* File: OPAD04.sp
* Created: Wed Apr 29 12:58:22 2026
* Program "Calibre xRC"
* Version "v2017.2_16.14"
*
.subckt OPAD04 VSS PAD IN1 VDD
M0 VDD IN1 PAD VDD P L=1.8e-06 W=9e-05 AD=6.21e-10 AS=6.12e-10 PD=0.0001938
+ PS=0.0001936 NRD=0.0566667 NRS=0.016
M1 PAD IN1 VDD VDD P L=1.8e-06 W=9e-05 AD=6.21e-10 AS=6.21e-10 PD=0.0001938
+ PS=0.0001938 NRD=0.0358333 NRS=0.0216667
M2 VDD IN1 PAD VDD P L=1.8e-06 W=9e-05 AD=3.33e-10 AS=6.21e-10 PD=0.0001874
+ PS=0.0001938 NRD=0.0566667 NRS=0.0156667
M3 VSS IN1 PAD VSS N L=1.5e-06 W=6.35e-05 AD=4.3815e-10 AS=4.2545e-10
+ PD=0.0001408 PS=0.0001404 NRD=0.0769029 NRS=0.0222047
M4 PAD IN1 VSS VSS N L=1.5e-06 W=6.35e-05 AD=4.7625e-10 AS=4.3815e-10
+ PD=0.000142 PS=0.0001408 NRD=0.0511811 NRS=0.0419573
M5 VSS IN1 PAD VSS N L=1.5e-06 W=6.35e-05 AD=4.6115e-10 AS=4.7625e-10
+ PD=0.0001416 PS=0.000142 NRD=0.0716535 NRS=0.023622
M6 PAD IN1 VSS VSS N L=1.5e-06 W=5.95e-05 AD=4.01625e-10 AS=4.6115e-10
+ PD=0.0001325 PS=0.0001416 NRD=0.0651261 NRS=0.0434174
D7 VSS PAD DNWELLPSUB  AREA=0.196343
.ends
*
*
* File: PVDD01.sp
* Created: Wed Apr 29 12:58:39 2026
* Program "Calibre xRC"
* Version "v2017.2_16.14"
*
.subckt PVDD01 VDD VSS
D0 VSS VDD DNWELLPSUB  AREA=0.166949
.ends
*
*
* File: PVSS01.sp
* Created: Wed Apr 29 12:58:41 2026
* Program "Calibre xRC"
* Version "v2017.2_16.14"
*
.subckt PVSS01 VSS VDD
D0 VSS VSS DNWELLPSUB  AREA=0.166949
.ends
*
*

.subckt IPAD00 VSS IN1 OUT1 VDD
XR0 IN1 OUT1 RNW W=45u L=14.5u
D1 VSS IN1 DNWELLPSUB  AREA=0.207105
D2 IN1 VDD DPDIFFNWELL  AREA=0.0104896
D3 OUT1 VDD DPDIFFNWELL  AREA=0.00302336
D4 VSS OUT1 DNDIFFPSUB  AREA=0.0154093
.ends

.subckt AIPAD00 VSS IN1 VDD
XR0 IN1 OUT1 RNW W=45u L=14.5u
D1 VSS IN1 DNWELLPSUB  AREA=0.207105
D2 IN1 VDD DPDIFFNWELL  AREA=0.0104896
D3 OUT1 VDD DPDIFFNWELL  AREA=0.00302336
D4 VSS OUT1 DNDIFFPSUB  AREA=0.0154093
.ends

.SUBCKT RNW N1 N2  W='W' L='L'
R1 N1 N2 '2680*(L/W)' RNW
.ENDS RNW

.SUBCKT RPP N1 N2  W='W' L='L'
R1 N1 N2   '31*(L/W)' RPP
.ENDS RPP

.SUBCKT RNP N1 N2  W='W' L='L'
R1 N1 N2   '23*(L/W)' RNP
.ENDS RNP

.SUBCKT RNDIFF N1 N2  W='W' L='L'
R1 N1 N2   '30*(L/W)' RNDIFF
.ENDS RNDIFF

.SUBCKT RPDIFF N1 N2  W='W' L='L'
R1 N1 N2   '68*(L/W)' RPDIFF
.ENDS RPDIFF
