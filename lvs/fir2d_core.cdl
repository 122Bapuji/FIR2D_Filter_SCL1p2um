*
*  /mnt/g/VLSI_Projects/FIR2D_Filter_SCL1p2um/lvs/fir2d_core.cdl : SPICE netlist translated from the VERILOG netlist : /mnt/g/VLSI_Projects/FIR2D_Filter_SCL1p2um/routing/fir2d_routed_pwr.v
*                                                                  on the 2026-10-03 17:42:58.333237
*
**********************************************************************************************************************************************************************************************

.INCLUDE core_iolib_c1d.cdl

.GLOBAL VDD VSS

.SUBCKT FIR2D_TOP CLK FRAME_DONE LINE_DONE RST_N VALID_IN VALID_OUT MODE[0] MODE[1] PIXEL_IN[0] PIXEL_IN[1] PIXEL_IN[2] PIXEL_IN[3] PIXEL_IN[4] PIXEL_IN[5] PIXEL_IN[6] PIXEL_IN[7] PIXEL_OUT[0] PIXEL_OUT[1] PIXEL_OUT[2] PIXEL_OUT[3] PIXEL_OUT[4] PIXEL_OUT[5] PIXEL_OUT[6] PIXEL_OUT[7] VDD VSS

X_1299_ _1294_[0] _0013_ VDD VSS INVR01
X_1300_ _1293_[0] _0014_ VDD VSS INVR01
X_1301_ _1297_[3] _0015_ VDD VSS INVR01
X_1302_ _1295_[3] _0016_ VDD VSS INVR01
X_1303_ ROW_CNT[1] _1295_[2] ROW_CNT[2] _0017_ VDD VSS ADNR01
X_1304_ ROW_CNT[4] _1295_[4] _0018_ VSS VDD OR2101
X_1305_ ROW_CNT[3] ROW_CNT[4] _0019_ VDD VSS NOR200
X_1306_ _0016_ _0017_ _0019_ _0020_ VSS VDD ORND01
X_1307_ COL_CNT[1] _1297_[2] COL_CNT[2] _0021_ VDD VSS ADNR01
X_1308_ COL_CNT[3] COL_CNT[4] _0022_ VDD VSS NOR200
X_1309_ _0015_ _0021_ _0022_ _0023_ VSS VDD ORND01
X_1310_ COL_CNT[4] _1297_[4] _0024_ VSS VDD OR2101
X_1311_ _0024_ _0023_ _0020_ _0018_ VALID_IN _0025_ VDD VSS AND501
X_1312_ WINDOW_READY _0025_ _0002_ VSS VDD OR2101
X_1313_ COL_CNT[3] COL_CNT[4] _1298_[1] _1297_[2] _0026_ VSS VDD NOR401
X_1314_ _0026_ _0013_ VALID_IN _0001_ VDD VSS AND301
X_1315_ _0001_ ROW_CNT[0] _0003_ _1293_[0] VDD VSS MX2101
X_1316_ _1296_[1] _1295_[2] _0027_ VDD VSS NOR200
X_1317_ _0027_ _0001_ _0019_ _0014_ _0000_ VDD VSS AND401
X_1318_ _0026_ _0013_ VALID_IN ROW_CNT[1] ROW_CNT[0] _0028_ VDD VSS AND501
X_1319_ ROW_CNT[0] _0001_ ROW_CNT[1] _0029_ VDD VSS ADNR01
X_1320_ _0000_ _0028_ _0029_ _0004_ VDD VSS NOR300
X_1321_ ROW_CNT[2] _0028_ _0030_ VSS VDD AND201
X_1322_ ROW_CNT[2] _0028_ _0031_ VDD VSS NOR200
X_1323_ _0000_ _0030_ _0031_ _0005_ VDD VSS NOR300
X_1324_ _0028_ ROW_CNT[3] ROW_CNT[2] _0032_ VDD VSS AND301
X_1325_ ROW_CNT[2] _0028_ ROW_CNT[3] _0033_ VDD VSS ADNR01
X_1326_ _0000_ _0032_ _0033_ _0006_ VDD VSS NOR300
X_1327_ ROW_CNT[4] _0032_ _0007_ VSS VDD XOR201
X_1328_ VALID_IN COL_CNT[0] _0008_ _1294_[0] VDD VSS MX2101
X_1329_ COL_CNT[0] VALID_IN COL_CNT[1] _0034_ VDD VSS ADNR01
X_1330_ COL_CNT[1] VALID_IN COL_CNT[0] _0035_ VDD VSS AND301
X_1331_ _0001_ _0034_ _0035_ _0009_ VDD VSS NOR300
X_1332_ COL_CNT[2] _0035_ _0036_ VSS VDD AND201
X_1333_ COL_CNT[2] _0035_ _0037_ VDD VSS NOR200
X_1334_ _0001_ _0036_ _0037_ _0010_ VDD VSS NOR300
X_1335_ COL_CNT[3] _0036_ _0038_ VSS VDD AND201
X_1336_ COL_CNT[3] _0036_ _0039_ VDD VSS NOR200
X_1337_ _0001_ _0038_ _0039_ _0011_ VDD VSS NOR300
X_1338_ COL_CNT[4] _0038_ _0012_ VSS VDD XOR201
X_1339_ WINDOW_READY VALID_IN CONV_VALID_IN VSS VDD AND201
X_1340_ CLKNET_5_29__LEAF_CLK _0001_ RST_N _0042_ LINE_DONE VSS VDD DFCL11
X_1341_ CLKNET_5_28__LEAF_CLK _0000_ RST_N _0041_ FRAME_DONE VSS VDD DFCL11
X_1342_ CLKNET_5_29__LEAF_CLK _0002_ RST_N _0040_ WINDOW_READY VSS VDD DFCL11
X_1343_ CLKNET_5_28__LEAF_CLK _0003_ RST_N _1293_[0] ROW_CNT[0] VSS VDD DFCL11
X_1344_ CLKNET_5_31__LEAF_CLK _0004_ RST_N _1296_[1] ROW_CNT[1] VSS VDD DFCL11
X_1345_ CLKNET_5_28__LEAF_CLK _0005_ RST_N _1295_[2] ROW_CNT[2] VSS VDD DFCL11
X_1346_ CLKNET_5_28__LEAF_CLK _0006_ RST_N _1295_[3] ROW_CNT[3] VSS VDD DFCL11
X_1347_ CLKNET_5_28__LEAF_CLK _0007_ RST_N _1295_[4] ROW_CNT[4] VSS VDD DFCL11
X_1348_ CLKNET_5_30__LEAF_CLK _0008_ RST_N _1294_[0] COL_CNT[0] VSS VDD DFCL11
X_1349_ CLKNET_5_31__LEAF_CLK _0009_ RST_N _1298_[1] COL_CNT[1] VSS VDD DFCL11
X_1350_ CLKNET_5_31__LEAF_CLK _0010_ RST_N _1297_[2] COL_CNT[2] VSS VDD DFCL11
X_1351_ CLKNET_5_30__LEAF_CLK _0011_ RST_N _1297_[3] COL_CNT[3] VSS VDD DFCL11
X_1352_ CLKNET_5_30__LEAF_CLK _0012_ RST_N _1297_[4] COL_CNT[4] VSS VDD DFCL11
X_1353_ MODE[1] _0047_ VDD VSS INVR01
X_1354_ MODE[0] _0048_ VDD VSS INVR01
X_1355_ P12[3] _0049_ VDD VSS INVR01
X_1356_ \U_CON _0050_ VDD VSS INVR01
X_1357_ P10[3] _0051_ VDD VSS INVR01
X_1358_ P10[6] _0052_ VDD VSS INVR01
X_1359_ \U_CON _0053_ VDD VSS INVR01
X_1360_ \U_CON _0054_ VDD VSS INVR01
X_1361_ \U_CON \U_CON _0055_ VSS VDD OR2101
X_1362_ _0044_ \U_CON _0056_ VDD VSS NOR200
X_1363_ \U_CON \U_CON _0057_ VSS VDD NND201
X_1364_ \U_CON \U_CON _0058_ VSS VDD XOR201
X_1365_ \U_CON _0058_ _0059_ VSS VDD NND201
X_1366_ \U_CON _0058_ _0060_ VSS VDD XNR201
X_1367_ \U_CON \U_CON _0061_ VSS VDD NND201
X_1368_ \U_CON \U_CON _0062_ VSS VDD NND201
X_1369_ \U_CON \U_CON _0063_ VSS VDD AND201
X_1370_ \U_CON \U_CON _0064_ VSS VDD NND201
X_1371_ \U_CON \U_CON _0065_ VSS VDD OR2101
X_1372_ _0064_ _0065_ _0066_ VSS VDD NND201
X_1373_ \U_CON \U_CON _0067_ VSS VDD NND201
X_1374_ \U_CON \U_CON _0068_ VDD VSS NOR200
X_1375_ \U_CON \U_CON _0069_ VSS VDD AND201
X_1376_ \U_CON \U_CON _0070_ VSS VDD NND201
X_1377_ \U_CON \U_CON _0071_ VSS VDD OR2101
X_1378_ _0070_ _0071_ _0072_ VSS VDD NND201
X_1379_ \U_CON \U_CON _0073_ VSS VDD NND201
X_1380_ \U_CON \U_CON _0074_ VSS VDD AND201
X_1381_ \U_CON \U_CON _0075_ VSS VDD NND201
X_1382_ \U_CON \U_CON _0076_ VSS VDD OR2101
X_1383_ _0075_ _0076_ _0077_ VSS VDD NND201
X_1384_ \U_CON \U_CON _0078_ VSS VDD NND201
X_1385_ \U_CON \U_CON _0079_ VDD VSS NOR200
X_1386_ \U_CON \U_CON _0080_ VSS VDD AND201
X_1387_ \U_CON \U_CON _0081_ VSS VDD NND201
X_1388_ \U_CON \U_CON _0082_ VSS VDD OR2101
X_1389_ _0081_ _0082_ _0083_ VSS VDD NND201
X_1390_ \U_CON \U_CON _0084_ VSS VDD NND201
X_1391_ \U_CON \U_CON _0085_ VSS VDD AND201
X_1392_ \U_CON \U_CON _0086_ VSS VDD NND201
X_1393_ \U_CON \U_CON _0087_ VSS VDD AND201
X_1394_ \U_CON \U_CON _0088_ VSS VDD NND201
X_1395_ \U_CON \U_CON _0089_ VDD VSS NOR200
X_1396_ \U_CON \U_CON _0090_ VSS VDD XOR201
X_1397_ _0057_ _0089_ _0088_ _0091_ VSS VDD ORND01
X_1398_ \U_CON \U_CON _0092_ VDD VSS NOR200
X_1399_ _0087_ _0092_ _0093_ VDD VSS NOR200
X_1400_ _0091_ _0093_ _0087_ _0094_ VDD VSS ADNR01
X_1401_ \U_CON \U_CON _0095_ VDD VSS NOR200
X_1402_ \U_CON \U_CON _0096_ VSS VDD XOR201
X_1403_ _0094_ _0095_ _0086_ _0097_ VSS VDD ORND01
X_1404_ \U_CON \U_CON _0098_ VDD VSS NOR200
X_1405_ _0085_ _0098_ _0099_ VDD VSS NOR200
X_1406_ _0097_ _0099_ _0085_ _0100_ VDD VSS ADNR01
X_1407_ \U_CON \U_CON _0101_ VDD VSS NOR200
X_1408_ \U_CON \U_CON _0102_ VSS VDD XOR201
X_1409_ _0100_ _0101_ _0084_ _0103_ VSS VDD ORND01
X_1410_ _0082_ _0103_ _0080_ _0104_ VDD VSS ADNR01
X_1411_ _0078_ _0104_ _0079_ _0105_ VDD VSS ADNR01
X_1412_ _0076_ _0105_ _0074_ _0106_ VDD VSS ADNR01
X_1413_ \U_CON \U_CON _0107_ VDD VSS NOR200
X_1414_ \U_CON \U_CON _0108_ VSS VDD XOR201
X_1415_ _0106_ _0107_ _0073_ _0109_ VSS VDD ORND01
X_1416_ _0071_ _0109_ _0069_ _0110_ VDD VSS ADNR01
X_1417_ _0067_ _0110_ _0068_ _0111_ VDD VSS ADNR01
X_1418_ _0065_ _0111_ _0063_ _0112_ VDD VSS ADNR01
X_1419_ \U_CON \U_CON _0113_ VDD VSS NOR200
X_1420_ \U_CON \U_CON _0114_ VSS VDD XOR201
X_1421_ _0112_ _0113_ _0062_ _0115_ VSS VDD ORND01
X_1422_ \U_CON \U_CON _0116_ VSS VDD XNR201
X_1423_ _0115_ _0116_ _0061_ _0117_ VSS VDD ORND01
X_1424_ _0117_ _0118_ VDD VSS INVR01
X_1425_ _0115_ _0116_ _0119_ VSS VDD XNR201
X_1426_ \U_CON _0119_ _0120_ VDD VSS NOR200
X_1427_ _0120_ _0121_ VDD VSS INVR01
X_1428_ _0112_ _0114_ _0122_ VSS VDD XNR201
X_1429_ \U_CON _0122_ _0123_ VSS VDD NND201
X_1430_ _0066_ _0111_ _0124_ VSS VDD XNR201
X_1431_ \U_CON _0124_ _0125_ VSS VDD AND201
X_1432_ \U_CON _0124_ _0126_ VSS VDD NND201
X_1433_ \U_CON \U_CON _0127_ VSS VDD XOR201
X_1434_ _0110_ _0127_ _0128_ VSS VDD XNR201
X_1435_ \U_CON _0128_ _0129_ VSS VDD NND201
X_1436_ \U_CON _0128_ _0130_ VSS VDD XNR201
X_1437_ _0072_ _0109_ _0131_ VSS VDD XNR201
X_1438_ \U_CON _0131_ _0132_ VSS VDD AND201
X_1439_ \U_CON _0131_ _0133_ VSS VDD NND201
X_1440_ _0106_ _0108_ _0134_ VSS VDD XNR201
X_1441_ \U_CON _0134_ _0135_ VSS VDD NND201
X_1442_ _0077_ _0105_ _0136_ VSS VDD XNR201
X_1443_ \U_CON _0136_ _0137_ VSS VDD AND201
X_1444_ \U_CON _0136_ _0138_ VSS VDD NND201
X_1445_ \U_CON \U_CON _0139_ VSS VDD XOR201
X_1446_ _0104_ _0139_ _0140_ VSS VDD XNR201
X_1447_ \U_CON _0140_ _0141_ VSS VDD NND201
X_1448_ \U_CON _0140_ _0142_ VSS VDD XNR201
X_1449_ _0083_ _0103_ _0143_ VSS VDD XNR201
X_1450_ \U_CON _0143_ _0144_ VSS VDD AND201
X_1451_ \U_CON _0143_ _0145_ VSS VDD NND201
X_1452_ _0100_ _0102_ _0146_ VSS VDD XNR201
X_1453_ \U_CON _0146_ _0147_ VSS VDD NND201
X_1454_ _0097_ _0099_ _0148_ VSS VDD XNR201
X_1455_ _0054_ _0148_ _0149_ VDD VSS NOR200
X_1456_ _0094_ _0096_ _0150_ VSS VDD XNR201
X_1457_ \U_CON _0150_ _0151_ VSS VDD NND201
X_1458_ _0091_ _0093_ _0152_ VSS VDD XNR201
X_1459_ _0053_ _0152_ _0153_ VDD VSS NOR200
X_1460_ _0057_ _0090_ _0154_ VSS VDD XNR201
X_1461_ \U_CON _0154_ _0155_ VSS VDD NND201
X_1462_ \U_CON _0154_ _0156_ VSS VDD XNR201
X_1463_ _0059_ _0156_ _0155_ _0157_ VSS VDD ORND01
X_1464_ \U_CON _0152_ _0158_ VSS VDD XNR201
X_1465_ _0157_ _0158_ _0153_ _0159_ VDD VSS ADNR01
X_1466_ \U_CON _0150_ _0160_ VSS VDD XNR201
X_1467_ _0159_ _0160_ _0151_ _0161_ VSS VDD ORND01
X_1468_ \U_CON _0148_ _0162_ VSS VDD XNR201
X_1469_ _0161_ _0162_ _0149_ _0163_ VDD VSS ADNR01
X_1470_ \U_CON _0146_ _0164_ VSS VDD XNR201
X_1471_ _0163_ _0164_ _0147_ _0165_ VSS VDD ORND01
X_1472_ \U_CON _0143_ _0166_ VSS VDD OR2101
X_1473_ _0145_ _0166_ _0167_ VSS VDD NND201
X_1474_ _0165_ _0166_ _0144_ _0168_ VDD VSS ADNR01
X_1475_ _0142_ _0168_ _0141_ _0169_ VSS VDD ORND01
X_1476_ \U_CON _0136_ _0170_ VSS VDD OR2101
X_1477_ _0138_ _0170_ _0171_ VSS VDD NND201
X_1478_ _0169_ _0170_ _0137_ _0172_ VDD VSS ADNR01
X_1479_ \U_CON _0134_ _0173_ VSS VDD XNR201
X_1480_ _0172_ _0173_ _0135_ _0174_ VSS VDD ORND01
X_1481_ \U_CON _0131_ _0175_ VSS VDD OR2101
X_1482_ _0133_ _0175_ _0176_ VSS VDD NND201
X_1483_ _0174_ _0175_ _0132_ _0177_ VDD VSS ADNR01
X_1484_ _0130_ _0177_ _0129_ _0178_ VSS VDD ORND01
X_1485_ \U_CON _0124_ _0179_ VSS VDD OR2101
X_1486_ _0126_ _0179_ _0180_ VSS VDD NND201
X_1487_ _0178_ _0179_ _0125_ _0181_ VDD VSS ADNR01
X_1488_ \U_CON _0122_ _0182_ VSS VDD XNR201
X_1489_ _0181_ _0182_ _0123_ _0183_ VSS VDD ORND01
X_1490_ _0183_ _0119_ \U_CON _0184_ VDD VSS MX201B
X_1491_ _0121_ _0184_ _0118_ _0185_ VDD VSS ADNR01
X_1492_ _0184_ _0121_ _0118_ _0186_ VDD VSS AND301
X_1493_ _0185_ _0186_ _0187_ VSS VDD OR2101
X_1494_ _0142_ _0168_ _0188_ VSS VDD XNR201
X_1495_ _0188_ _0189_ VDD VSS INVR01
X_1496_ _0165_ _0167_ _0190_ VSS VDD XOR201
X_1497_ _0190_ _0191_ VDD VSS INVR01
X_1498_ _0163_ _0164_ _0192_ VSS VDD XOR201
X_1499_ _0192_ _0193_ VDD VSS INVR01
X_1500_ _0161_ _0162_ _0194_ VSS VDD XNR201
X_1501_ _0194_ _0195_ VDD VSS INVR01
X_1502_ _0159_ _0160_ _0196_ VSS VDD XNR201
X_1503_ _0157_ _0158_ _0197_ VSS VDD XNR201
X_1504_ _0059_ _0156_ _0198_ VSS VDD XOR201
X_1505_ _0198_ _0199_ VDD VSS INVR01
X_1506_ _0060_ _0199_ _0200_ VSS VDD NND201
X_1507_ _0200_ _0201_ VDD VSS INVR01
X_1508_ _0197_ _0201_ _0202_ VSS VDD NND201
X_1509_ _0201_ _0197_ _0196_ _0203_ VSS VDD NND300
X_1510_ _0195_ _0203_ _0204_ VSS VDD OR2101
X_1511_ _0192_ _0204_ _0205_ VDD VSS NOR200
X_1512_ _0205_ _0206_ VDD VSS INVR01
X_1513_ _0190_ _0205_ _0207_ VSS VDD NND201
X_1514_ _0189_ _0207_ _0208_ VSS VDD OR2101
X_1515_ _0185_ _0186_ _0208_ _0209_ VSS VDD ORND01
X_1516_ _0174_ _0176_ _0210_ VSS VDD XOR201
X_1517_ _0210_ _0211_ VDD VSS INVR01
X_1518_ _0169_ _0171_ _0212_ VSS VDD XNR201
X_1519_ _0172_ _0173_ _0213_ VSS VDD XOR201
X_1520_ _0212_ _0213_ _0214_ VSS VDD OR2101
X_1521_ \U_CON _0119_ _0215_ VSS VDD XOR201
X_1522_ _0183_ _0215_ _0216_ VSS VDD XNR201
X_1523_ _0178_ _0180_ _0217_ VSS VDD XOR201
X_1524_ _0181_ _0182_ _0218_ VSS VDD XNR201
X_1525_ _0218_ _0217_ _0216_ _0219_ VSS VDD NND300
X_1526_ _0130_ _0177_ _0220_ VSS VDD XOR201
X_1527_ _0220_ _0219_ _0211_ _0214_ _0221_ VDD VSS OR4101
X_1528_ _0220_ _0213_ _0212_ _0211_ _0222_ VSS VDD NND401
X_1529_ _0222_ _0218_ _0216_ _0217_ _0223_ VDD VSS OR4101
X_1530_ _0209_ _0223_ _0221_ _0224_ VDD VSS MX201B
X_1531_ _0060_ _0224_ _0056_ _0225_ VDD VSS ADNR01
X_1532_ _0044_ \U_CON _0187_ _0226_ VDD VSS OR3101
X_1533_ _0060_ _0156_ _0227_ VSS VDD OR2101
X_1534_ _0196_ _0197_ _0227_ _0228_ VDD VSS NOR300
X_1535_ _0228_ _0195_ _0192_ _0191_ _0189_ _0229_ VDD VSS AND501
X_1536_ _0187_ _0229_ _0221_ _0230_ VDD VSS ADNR01
X_1537_ _0060_ _0230_ _0226_ _0231_ VDD VSS ADNR01
X_1538_ _0225_ _0231_ _0055_ _0232_ VSS VDD ORND01
X_1539_ _0055_ _0187_ _0233_ VDD VSS NOR200
X_1540_ _0195_ _0219_ _0233_ _0234_ VSS VDD ORND01
X_1541_ _0232_ _0234_ _0050_ _0043_[0] VDD VSS ADNR01
X_1542_ _0192_ _0219_ _0233_ _0235_ VSS VDD ORND01
X_1543_ _0185_ _0186_ _0200_ _0236_ VSS VDD ORND01
X_1544_ _0227_ _0200_ _0187_ _0237_ VSS VDD NND300
X_1545_ _0224_ _0237_ _0056_ _0238_ VDD VSS ADNR01
X_1546_ _0056_ _0221_ _0198_ _0239_ VDD VSS ADNR01
X_1547_ _0187_ _0239_ _0240_ VDD VSS NOR200
X_1548_ _0238_ _0240_ _0055_ _0241_ VSS VDD ORND01
X_1549_ _0235_ _0241_ _0050_ _0043_[1] VDD VSS ADNR01
X_1550_ _0191_ _0219_ _0233_ _0242_ VSS VDD ORND01
X_1551_ _0197_ _0230_ _0226_ _0243_ VDD VSS ADNR01
X_1552_ _0197_ _0236_ _0244_ VSS VDD XNR201
X_1553_ _0224_ _0244_ _0056_ _0245_ VDD VSS ADNR01
X_1554_ _0243_ _0245_ _0055_ _0246_ VSS VDD ORND01
X_1555_ _0242_ _0246_ _0050_ _0043_[2] VDD VSS ADNR01
X_1556_ _0189_ _0219_ _0233_ _0247_ VSS VDD ORND01
X_1557_ _0196_ _0230_ _0226_ _0248_ VDD VSS ADNR01
X_1558_ _0185_ _0186_ _0202_ _0249_ VSS VDD ORND01
X_1559_ _0196_ _0249_ _0250_ VSS VDD XNR201
X_1560_ _0224_ _0250_ _0056_ _0251_ VDD VSS ADNR01
X_1561_ _0248_ _0251_ _0055_ _0252_ VSS VDD ORND01
X_1562_ _0247_ _0252_ _0050_ _0043_[3] VDD VSS ADNR01
X_1563_ _0212_ _0219_ _0233_ _0253_ VSS VDD ORND01
X_1564_ _0194_ _0230_ _0226_ _0254_ VDD VSS ADNR01
X_1565_ _0185_ _0186_ _0203_ _0255_ VSS VDD ORND01
X_1566_ _0185_ _0186_ _0204_ _0256_ VSS VDD ORND01
X_1567_ _0194_ _0255_ _0257_ VSS VDD XNR201
X_1568_ _0224_ _0257_ _0056_ _0258_ VDD VSS ADNR01
X_1569_ _0254_ _0258_ _0055_ _0259_ VSS VDD ORND01
X_1570_ _0253_ _0259_ _0050_ _0043_[4] VDD VSS ADNR01
X_1571_ _0213_ _0219_ _0233_ _0260_ VSS VDD ORND01
X_1572_ _0193_ _0230_ _0226_ _0261_ VDD VSS ADNR01
X_1573_ _0193_ _0256_ _0262_ VSS VDD XNR201
X_1574_ _0224_ _0262_ _0056_ _0263_ VDD VSS ADNR01
X_1575_ _0261_ _0263_ _0055_ _0264_ VSS VDD ORND01
X_1576_ _0260_ _0264_ _0050_ _0043_[5] VDD VSS ADNR01
X_1577_ _0211_ _0219_ _0233_ _0265_ VSS VDD ORND01
X_1578_ _0190_ _0230_ _0226_ _0266_ VDD VSS ADNR01
X_1579_ _0185_ _0186_ _0206_ _0267_ VSS VDD ORND01
X_1580_ _0190_ _0267_ _0268_ VSS VDD XNR201
X_1581_ _0224_ _0268_ _0056_ _0269_ VDD VSS ADNR01
X_1582_ _0266_ _0269_ _0055_ _0270_ VSS VDD ORND01
X_1583_ _0265_ _0270_ _0050_ _0043_[6] VDD VSS ADNR01
X_1584_ _0219_ _0220_ _0233_ _0271_ VSS VDD ORND01
X_1585_ _0188_ _0230_ _0226_ _0272_ VDD VSS ADNR01
X_1586_ _0185_ _0186_ _0207_ _0273_ VSS VDD ORND01
X_1587_ _0188_ _0273_ _0274_ VSS VDD XNR201
X_1588_ _0224_ _0274_ _0056_ _0275_ VDD VSS ADNR01
X_1589_ _0272_ _0275_ _0055_ _0276_ VSS VDD ORND01
X_1590_ _0271_ _0276_ _0050_ _0043_[7] VDD VSS ADNR01
X_1591_ MODE[1] _0048_ _0277_ VDD VSS NOR200
X_1592_ _0047_ MODE[0] _0278_ VSS VDD NND201
X_1593_ P02[0] _0278_ _0279_ VSS VDD NND201
X_1594_ MODE[0] P01[0] _0280_ VSS VDD NND201
X_1595_ MODE[1] P00[0] _0281_ VSS VDD AND201
X_1596_ _0281_ P01[0] MODE[0] _0282_ VSS VDD NND300
X_1597_ P00[0] _0278_ _0283_ VSS VDD NND201
X_1598_ _0280_ _0281_ _0284_ _0283_ VDD VSS MX2101
X_1599_ _0279_ _0284_ _0285_ VDD VSS NOR200
X_1600_ P00[1] _0281_ _0286_ VSS VDD XNR201
X_1601_ _0277_ _0286_ _0287_ VDD VSS NOR200
X_1602_ MODE[0] P01[1] _0288_ VSS VDD AND201
X_1603_ _0047_ MODE[0] _0289_ VDD VSS NOR200
X_1604_ MODE[1] _0048_ _0290_ VSS VDD NND201
X_1605_ P01[0] _0290_ _0288_ _0291_ VDD VSS ADNR01
X_1606_ MODE[1] MODE[0] _0292_ VDD VSS NOR200
X_1607_ _0047_ _0048_ _0293_ VSS VDD NND201
X_1608_ P01[0] _0288_ _0291_ _0294_ VDD VSS ADNR01
X_1609_ _0287_ _0294_ _0295_ VSS VDD AND201
X_1610_ _0287_ _0294_ _0296_ VSS VDD XNR201
X_1611_ _0282_ _0296_ _0297_ VDD VSS NOR200
X_1612_ _0282_ _0296_ _0298_ VSS VDD XNR201
X_1613_ MODE[0] P02[0] _0299_ VSS VDD NND201
X_1614_ P02[1] _0299_ _0300_ VSS VDD XOR201
X_1615_ _0277_ _0300_ _0301_ VDD VSS NOR200
X_1616_ _0277_ _0298_ _0300_ _0302_ VDD VSS OR3101
X_1617_ _0298_ _0301_ _0303_ VSS VDD XNR201
X_1618_ _0285_ _0303_ _0304_ VSS VDD NND201
X_1619_ _0285_ _0303_ _0888_[1] VSS VDD XOR201
X_1620_ _0295_ _0297_ _0305_ VDD VSS NOR200
X_1621_ P00[0] P00[1] P00[2] _0306_ VSS VDD ORND01
X_1622_ P00[0] P00[1] P00[2] _0307_ VDD VSS OR3101
X_1623_ MODE[1] _0307_ _0308_ VSS VDD NND201
X_1624_ _0307_ _0306_ MODE[1] _0309_ VSS VDD NND300
X_1625_ P00[2] _0292_ _0310_ VSS VDD NND201
X_1626_ _0309_ _0310_ _0311_ VSS VDD NND201
X_1627_ P01[1] _0292_ _0312_ VSS VDD NND201
X_1628_ P01[0] P01[1] P01[2] _0313_ VSS VDD ORND01
X_1629_ P01[0] P01[1] P01[2] _0314_ VDD VSS OR3101
X_1630_ _0314_ _0313_ MODE[0] _0315_ VSS VDD NND300
X_1631_ _0312_ _0315_ _0316_ VSS VDD NND201
X_1632_ _0311_ _0316_ _0317_ VSS VDD NND201
X_1633_ _0311_ _0316_ _0318_ VSS VDD XOR201
X_1634_ _0295_ _0297_ _0318_ _0319_ VSS VDD ORND01
X_1635_ _0305_ _0318_ _0320_ VSS VDD XNR201
X_1636_ P02[0] P02[1] _0321_ VSS VDD OR2101
X_1637_ MODE[0] _0321_ _0322_ VSS VDD NND201
X_1638_ P02[2] _0322_ _0323_ VSS VDD XNR201
X_1639_ _0323_ _0320_ _0278_ _0324_ VDD VSS AND301
X_1640_ _0278_ _0323_ _0320_ _0325_ VDD VSS ADNR01
X_1641_ _0324_ _0325_ _0326_ VSS VDD OR2101
X_1642_ _0302_ _0304_ _0326_ _0327_ VDD VSS ADNR01
X_1643_ _0326_ _0304_ _0302_ _0328_ VDD VSS AND301
X_1644_ _0327_ _0328_ _0888_[2] VDD VSS NOR200
X_1645_ P02[2] _0321_ _0329_ VSS VDD OR2101
X_1646_ MODE[0] _0329_ _0330_ VSS VDD NND201
X_1647_ P02[3] _0330_ _0331_ VSS VDD XOR201
X_1648_ _0277_ _0331_ _0332_ VDD VSS NOR200
X_1649_ _0317_ _0319_ _0333_ VSS VDD NND201
X_1650_ P01[2] _0292_ _0334_ VSS VDD NND201
X_1651_ P01[3] _0314_ _0335_ VSS VDD OR2101
X_1652_ P01[3] _0314_ _0048_ _0336_ VDD VSS ADNR01
X_1653_ _0335_ _0336_ _0337_ VSS VDD NND201
X_1654_ _0334_ _0337_ _0338_ VSS VDD NND201
X_1655_ P00[3] _0278_ _0339_ VSS VDD NND201
X_1656_ _0308_ P00[3] _0340_ _0339_ VDD VSS MX2101
X_1657_ _0334_ _0337_ _0340_ _0341_ VDD VSS ADNR01
X_1658_ _0338_ _0340_ _0342_ VSS VDD XNR201
X_1659_ _0333_ _0342_ _0343_ VSS VDD XOR201
X_1660_ _0332_ _0343_ _0344_ VSS VDD NND201
X_1661_ _0332_ _0343_ _0345_ VSS VDD XOR201
X_1662_ _0324_ _0327_ _0345_ _0346_ VSS VDD ORND01
X_1663_ _0324_ _0327_ _0345_ _0347_ VDD VSS OR3101
X_1664_ _0346_ _0347_ _0888_[3] VSS VDD AND201
X_1665_ _0333_ _0342_ _0341_ _0348_ VDD VSS ADNR01
X_1666_ P00[3] _0307_ _0349_ VSS VDD OR2101
X_1667_ P00[4] _0349_ MODE[1] _0350_ VSS VDD ORND01
X_1668_ P00[4] _0349_ _0350_ _0351_ VDD VSS ADNR01
X_1669_ P00[4] _0292_ _0351_ _0352_ VDD VSS ADNR01
X_1670_ _0352_ _0353_ VDD VSS INVR01
X_1671_ P01[3] _0292_ _0354_ VSS VDD NND201
X_1672_ P01[4] _0335_ _0355_ VSS VDD OR2101
X_1673_ P01[4] _0335_ _0048_ _0356_ VDD VSS ADNR01
X_1674_ _0355_ _0356_ _0357_ VSS VDD NND201
X_1675_ _0354_ _0357_ _0358_ VSS VDD NND201
X_1676_ _0353_ _0358_ _0359_ VSS VDD XNR201
X_1677_ _0348_ _0359_ _0360_ VDD VSS NOR200
X_1678_ _0348_ _0359_ _0361_ VSS VDD XNR201
X_1679_ P02[3] _0329_ _0362_ VSS VDD OR2101
X_1680_ MODE[0] _0362_ P02[4] _0363_ VDD VSS ADNR01
X_1681_ _0362_ P02[4] MODE[0] _0364_ VSS VDD NND300
X_1682_ _0278_ _0364_ _0365_ VSS VDD NND201
X_1683_ _0363_ _0365_ _0366_ VDD VSS NOR200
X_1684_ _0361_ _0363_ _0365_ _0367_ VDD VSS NOR300
X_1685_ _0361_ _0366_ _0368_ VSS VDD XOR201
X_1686_ _0344_ _0346_ _0368_ _0369_ VDD VSS ADNR01
X_1687_ _0368_ _0346_ _0344_ _0370_ VDD VSS AND301
X_1688_ _0369_ _0370_ _0888_[4] VDD VSS NOR200
X_1689_ _0367_ _0369_ _0371_ VDD VSS NOR200
X_1690_ P02[4] _0362_ _0372_ VSS VDD OR2101
X_1691_ MODE[0] _0372_ _0373_ VSS VDD NND201
X_1692_ P02[5] _0373_ _0374_ VSS VDD XOR201
X_1693_ _0277_ _0374_ _0375_ VDD VSS NOR200
X_1694_ _0353_ _0358_ _0360_ _0376_ VDD VSS ADNR01
X_1695_ P01[5] _0355_ _0377_ VSS VDD OR2101
X_1696_ MODE[0] _0377_ _0378_ VSS VDD NND201
X_1697_ P01[5] _0355_ _0378_ _0379_ VDD VSS ADNR01
X_1698_ P01[4] _0292_ _0379_ _0380_ VDD VSS ADNR01
X_1699_ P00[5] _0278_ _0381_ VSS VDD NND201
X_1700_ _0350_ P00[5] _0382_ _0381_ VDD VSS MX2101
X_1701_ _0380_ _0382_ _0383_ VDD VSS NOR200
X_1702_ _0380_ _0382_ _0384_ VSS VDD XOR201
X_1703_ _0384_ _0385_ VDD VSS INVR01
X_1704_ _0376_ _0385_ _0386_ VDD VSS NOR200
X_1705_ _0376_ _0384_ _0387_ VSS VDD XNR201
X_1706_ _0375_ _0387_ _0388_ VSS VDD NND201
X_1707_ _0375_ _0387_ _0389_ VSS VDD XOR201
X_1708_ _0367_ _0369_ _0389_ _0390_ VSS VDD ORND01
X_1709_ _0371_ _0389_ _0888_[5] VSS VDD XNR201
X_1710_ _0383_ _0386_ _0391_ VDD VSS NOR200
X_1711_ P00[4] P00[5] _0349_ _0392_ VDD VSS OR3101
X_1712_ P00[6] _0392_ _0393_ VSS VDD AND201
X_1713_ P00[6] _0392_ MODE[1] _0394_ VSS VDD ORND01
X_1714_ P00[6] _0292_ _0395_ VSS VDD NND201
X_1715_ _0393_ _0394_ _0395_ _0396_ VSS VDD ORND01
X_1716_ P01[5] _0292_ _0397_ VSS VDD NND201
X_1717_ P01[6] _0377_ _0398_ VSS VDD NND201
X_1718_ P01[6] _0377_ _0399_ VSS VDD OR2101
X_1719_ MODE[0] _0399_ _0400_ VSS VDD AND201
X_1720_ _0398_ _0400_ _0401_ VSS VDD NND201
X_1721_ _0397_ _0401_ _0402_ VSS VDD NND201
X_1722_ _0396_ _0402_ _0403_ VSS VDD NND201
X_1723_ _0396_ _0402_ _0404_ VSS VDD XOR201
X_1724_ _0383_ _0386_ _0404_ _0405_ VSS VDD ORND01
X_1725_ _0391_ _0404_ _0406_ VSS VDD XNR201
X_1726_ P02[5] _0372_ _0407_ VSS VDD OR2101
X_1727_ MODE[0] _0407_ _0408_ VSS VDD NND201
X_1728_ P02[6] _0408_ _0409_ VSS VDD XOR201
X_1729_ _0277_ _0409_ _0410_ VDD VSS NOR200
X_1730_ _0406_ _0410_ _0411_ VSS VDD XNR201
X_1731_ _0388_ _0390_ _0411_ _0412_ VDD VSS ADNR01
X_1732_ _0411_ _0390_ _0388_ _0413_ VDD VSS AND301
X_1733_ _0412_ _0413_ _0888_[6] VDD VSS NOR200
X_1734_ _0406_ _0410_ _0412_ _0414_ VDD VSS ADNR01
X_1735_ P02[6] _0407_ _0415_ VSS VDD OR2101
X_1736_ MODE[0] _0415_ _0416_ VSS VDD NND201
X_1737_ P02[7] _0416_ _0417_ VSS VDD XOR201
X_1738_ _0277_ _0417_ _0418_ VDD VSS NOR200
X_1739_ P01[7] _0399_ _0419_ VSS VDD NND201
X_1740_ P01[7] _0399_ _0420_ VDD VSS NOR200
X_1741_ _0048_ _0420_ _0421_ VDD VSS NOR200
X_1742_ _0419_ _0421_ _0422_ VSS VDD NND201
X_1743_ P01[6] _0292_ _0423_ VSS VDD NND201
X_1744_ _0422_ _0423_ _0424_ VSS VDD NND201
X_1745_ _0424_ _0425_ VDD VSS INVR01
X_1746_ MODE[1] P00[7] _0426_ VSS VDD NND201
X_1747_ P00[7] _0278_ _0427_ VSS VDD NND201
X_1748_ _0394_ P00[7] _0428_ _0427_ VDD VSS MX2101
X_1749_ _0425_ _0428_ _0429_ VDD VSS NOR200
X_1750_ _0425_ _0428_ _0430_ VSS VDD XNR201
X_1751_ _0403_ _0405_ _0430_ _0431_ VDD VSS ADNR01
X_1752_ _0430_ _0405_ _0403_ _0432_ VDD VSS AND301
X_1753_ _0431_ _0432_ _0433_ VDD VSS NOR200
X_1754_ _0418_ _0433_ _0434_ VSS VDD NND201
X_1755_ _0418_ _0433_ _0435_ VSS VDD XNR201
X_1756_ _0414_ _0435_ _0436_ VSS VDD OR2101
X_1757_ _0414_ _0435_ _0888_[7] VSS VDD XOR201
X_1758_ _0047_ _0048_ _0437_ VDD VSS NOR200
X_1759_ P02[7] _0415_ _0437_ _0438_ VSS VDD ORND01
X_1760_ _0429_ _0431_ _0439_ VDD VSS NOR200
X_1761_ _0394_ _0426_ _0440_ VSS VDD NND201
X_1762_ P01[7] _0400_ _0290_ _0441_ VSS VDD ORND01
X_1763_ _0440_ _0441_ _0442_ VSS VDD XOR201
X_1764_ _0439_ _0442_ _0443_ VSS VDD XNR201
X_1765_ _0438_ _0443_ _0444_ VDD VSS NOR200
X_1766_ _0438_ _0443_ _0445_ VSS VDD XNR201
X_1767_ _0434_ _0436_ _0445_ _0446_ VDD VSS ADNR01
X_1768_ _0445_ _0436_ _0434_ _0447_ VDD VSS AND301
X_1769_ _0446_ _0447_ _0888_[8] VDD VSS NOR200
X_1770_ _0421_ _0440_ _0448_ VDD VSS NOR200
X_1771_ _0439_ _0442_ _0448_ _0449_ VSS VDD ORND01
X_1772_ _0438_ _0449_ _0450_ VSS VDD XNR201
X_1773_ _0444_ _0446_ _0450_ _0451_ VDD VSS NOR300
X_1774_ _0446_ _0450_ _0451_ _0888_[9] VDD VSS ADNR01
X_1775_ _0438_ _0448_ _0450_ _0446_ _0888_[10] VDD VSS AOI401
X_1776_ _0279_ _0284_ _0887_[0] VSS VDD XOR201
X_1777_ MODE[0] P12[0] _0452_ VSS VDD NND201
X_1778_ P11[0] _0277_ _0453_ VSS VDD NND201
X_1779_ _0277_ P10[0] P11[0] _0454_ VSS VDD NND300
X_1780_ MODE[0] P10[0] _0455_ VSS VDD NND201
X_1781_ _0453_ P10[0] _0456_ _0455_ VDD VSS MX2101
X_1782_ _0452_ _0456_ _0457_ VDD VSS NOR200
X_1783_ P11[1] _0277_ _0458_ VSS VDD NND201
X_1784_ P10[0] P10[1] _0459_ VDD VSS NOR200
X_1785_ P10[0] P10[1] _0460_ VSS VDD XOR201
X_1786_ MODE[0] P10[0] _0461_ _0460_ VDD VSS MX2101
X_1787_ _0461_ _0277_ P11[1] _0462_ VSS VDD NND300
X_1788_ _0458_ _0461_ _0463_ VSS VDD XOR201
X_1789_ _0454_ _0463_ _0464_ VSS VDD OR2101
X_1790_ _0454_ _0463_ _0465_ VSS VDD NND201
X_1791_ _0464_ _0465_ _0466_ VSS VDD NND201
X_1792_ MODE[0] P12[1] _0467_ VSS VDD NND201
X_1793_ P12[0] _0467_ _0468_ VSS VDD XOR201
X_1794_ _0466_ _0468_ _0469_ VDD VSS NOR200
X_1795_ _0466_ _0468_ _0470_ VSS VDD XOR201
X_1796_ _0457_ _0470_ _0890_[1] VSS VDD XOR201
X_1797_ _0457_ _0470_ _0469_ _0471_ VDD VSS ADNR01
X_1798_ P10[0] P10[1] P10[2] _0472_ VDD VSS NOR300
X_1799_ P10[2] _0459_ _0473_ VSS VDD XNR201
X_1800_ MODE[0] _0473_ _0474_ VSS VDD NND201
X_1801_ _0289_ _0460_ _0475_ VSS VDD NND201
X_1802_ _0474_ _0475_ _0476_ VSS VDD NND201
X_1803_ P10[1] _0292_ _0476_ _0477_ VDD VSS ADNR01
X_1804_ P11[0] P11[2] _0478_ VSS VDD NND201
X_1805_ MODE[0] P11[2] _0479_ VSS VDD NND201
X_1806_ P11[0] _0479_ _0480_ VSS VDD XOR201
X_1807_ MODE[1] _0480_ _0481_ VDD VSS NOR200
X_1808_ _0481_ _0482_ VDD VSS INVR01
X_1809_ _0477_ _0482_ _0483_ VDD VSS NOR200
X_1810_ _0477_ _0482_ _0484_ VSS VDD XNR201
X_1811_ _0462_ _0464_ _0484_ _0485_ VDD VSS ADNR01
X_1812_ _0484_ _0464_ _0462_ _0486_ VDD VSS AND301
X_1813_ _0485_ _0486_ _0487_ VDD VSS NOR200
X_1814_ MODE[0] P12[2] _0488_ VSS VDD NND201
X_1815_ MODE[0] P12[0] P12[1] _0489_ VDD VSS ADNR01
X_1816_ _0488_ _0489_ _0490_ VSS VDD XOR201
X_1817_ _0487_ _0490_ _0491_ VSS VDD NND201
X_1818_ _0487_ _0490_ _0492_ VDD VSS NOR200
X_1819_ _0487_ _0490_ _0493_ VSS VDD XOR201
X_1820_ _0471_ _0493_ _0890_[2] VSS VDD XNR201
X_1821_ _0471_ _0492_ _0491_ _0494_ VSS VDD ORND01
X_1822_ _0483_ _0485_ _0495_ VSS VDD OR2101
X_1823_ _0051_ _0472_ _0496_ VSS VDD NND201
X_1824_ P10[3] _0472_ _0497_ VSS VDD XNR201
X_1825_ _0292_ P10[2] _0473_ _0289_ _0497_ MODE[0] _0498_ VSS VDD ADOR16
X_1826_ P11[1] P11[3] _0499_ VSS VDD AND201
X_1827_ P11[1] P11[3] _0500_ VDD VSS NOR200
X_1828_ _0499_ _0500_ _0478_ _0501_ VSS VDD ORND01
X_1829_ _0478_ _0499_ _0500_ _0502_ VDD VSS NOR300
X_1830_ _0278_ _0502_ _0503_ VDD VSS NOR200
X_1831_ _0292_ P11[1] _0501_ _0503_ _0437_ P11[0] _0504_ VSS VDD ADOR16
X_1832_ _0498_ _0504_ _0505_ VSS VDD NND201
X_1833_ _0498_ _0504_ _0506_ VSS VDD OR2101
X_1834_ _0505_ _0506_ _0507_ VSS VDD NND201
X_1835_ _0495_ _0507_ _0508_ VSS VDD XNR201
X_1836_ P12[0] P12[1] P12[2] _0509_ VDD VSS NOR300
X_1837_ _0049_ _0509_ _0510_ VSS VDD NND201
X_1838_ P12[3] _0509_ _0511_ VSS VDD XNR201
X_1839_ MODE[0] P12[2] _0512_ _0511_ VDD VSS MX2101
X_1840_ _0508_ _0512_ _0513_ VSS VDD NND201
X_1841_ _0508_ _0512_ _0514_ VSS VDD XNR201
X_1842_ _0514_ _0515_ VDD VSS INVR01
X_1843_ _0494_ _0515_ _0516_ VSS VDD NND201
X_1844_ _0494_ _0514_ _0890_[3] VSS VDD XNR201
X_1845_ _0513_ _0516_ _0517_ VSS VDD NND201
X_1846_ P10[4] _0496_ _0518_ VDD VSS NOR200
X_1847_ P10[4] _0496_ _0519_ VSS VDD XOR201
X_1848_ _0292_ P10[3] _0497_ _0289_ _0519_ MODE[0] _0520_ VSS VDD ADOR16
X_1849_ _0499_ _0502_ _0521_ VSS VDD OR2101
X_1850_ P11[2] P11[4] _0522_ VSS VDD AND201
X_1851_ P11[2] P11[4] _0523_ VSS VDD NND201
X_1852_ P11[2] P11[4] _0524_ VSS VDD OR2101
X_1853_ _0523_ _0524_ _0525_ VSS VDD NND201
X_1854_ _0521_ _0525_ _0526_ VSS VDD XNR201
X_1855_ _0292_ P11[2] _0526_ _0277_ _0437_ P11[1] _0527_ VSS VDD ADOR16
X_1856_ _0520_ _0527_ _0528_ VSS VDD NND201
X_1857_ _0528_ _0529_ VDD VSS INVR01
X_1858_ _0520_ _0527_ _0530_ VDD VSS NOR200
X_1859_ _0529_ _0530_ _0531_ VDD VSS NOR200
X_1860_ _0495_ _0506_ _0532_ VSS VDD NND201
X_1861_ _0505_ _0532_ _0533_ VSS VDD NND201
X_1862_ _0531_ _0533_ _0534_ VSS VDD XOR201
X_1863_ P12[4] _0510_ _0535_ VDD VSS NOR200
X_1864_ P12[4] _0510_ _0536_ VSS VDD XOR201
X_1865_ MODE[0] P12[3] _0537_ _0536_ VDD VSS MX2101
X_1866_ _0534_ _0537_ _0538_ VSS VDD NND201
X_1867_ _0534_ _0537_ _0539_ VSS VDD XOR201
X_1868_ _0517_ _0539_ _0540_ VSS VDD NND201
X_1869_ _0517_ _0539_ _0890_[4] VSS VDD XOR201
X_1870_ _0538_ _0540_ _0541_ VSS VDD NND201
X_1871_ _0531_ _0533_ _0529_ _0542_ VDD VSS ADNR01
X_1872_ P10[4] P10[5] _0496_ _0543_ VDD VSS NOR300
X_1873_ P10[5] _0518_ _0544_ VSS VDD XNR201
X_1874_ _0292_ P10[4] _0519_ _0289_ _0544_ MODE[0] _0545_ VSS VDD ADOR16
X_1875_ _0521_ _0524_ _0522_ _0546_ VDD VSS ADNR01
X_1876_ P11[3] P11[5] _0547_ VSS VDD NND201
X_1877_ P11[3] P11[5] _0548_ VDD VSS NOR200
X_1878_ P11[3] P11[5] _0549_ VSS VDD XOR201
X_1879_ _0546_ _0549_ _0550_ VSS VDD XNR201
X_1880_ _0047_ P11[3] _0551_ VSS VDD NND201
X_1881_ _0479_ _0551_ _0552_ VSS VDD NND201
X_1882_ _0278_ _0550_ _0553_ _0552_ VDD VSS MX2101
X_1883_ _0545_ _0553_ _0554_ VSS VDD NND201
X_1884_ _0545_ _0553_ _0555_ VSS VDD XNR201
X_1885_ _0542_ _0555_ _0556_ VSS VDD OR2101
X_1886_ _0542_ _0555_ _0557_ VSS VDD XNR201
X_1887_ _0557_ _0558_ VDD VSS INVR01
X_1888_ P12[4] P12[5] _0510_ _0559_ VDD VSS OR3101
X_1889_ P12[5] _0535_ _0560_ VSS VDD XNR201
X_1890_ MODE[0] P12[4] _0561_ _0560_ VDD VSS MX2101
X_1891_ _0558_ _0561_ _0562_ VSS VDD NND201
X_1892_ _0557_ _0561_ _0563_ VSS VDD XNR201
X_1893_ _0541_ _0563_ _0564_ VSS VDD NND201
X_1894_ _0541_ _0563_ _0890_[5] VSS VDD XOR201
X_1895_ P12[6] _0559_ _0565_ VSS VDD OR2101
X_1896_ MODE[0] _0565_ _0566_ VSS VDD NND201
X_1897_ P12[6] _0559_ _0566_ _0567_ VDD VSS ADNR01
X_1898_ _0048_ P12[5] _0567_ _0568_ VDD VSS ADNR01
X_1899_ _0554_ _0556_ _0569_ VSS VDD NND201
X_1900_ _0052_ _0543_ _0570_ VSS VDD NND201
X_1901_ P10[6] _0543_ _0571_ VSS VDD XNR201
X_1902_ _0292_ P10[5] _0544_ _0289_ _0571_ MODE[0] _0572_ VSS VDD ADOR16
X_1903_ _0546_ _0548_ _0547_ _0573_ VSS VDD ORND01
X_1904_ P11[4] P11[6] _0574_ VSS VDD NND201
X_1905_ P11[4] P11[6] _0575_ VSS VDD XOR201
X_1906_ _0573_ _0575_ _0576_ VDD VSS NOR200
X_1907_ _0573_ _0575_ _0577_ VSS VDD NND201
X_1908_ _0278_ _0576_ _0578_ VDD VSS NOR200
X_1909_ _0292_ P11[4] _0577_ _0578_ _0437_ P11[3] _0579_ VSS VDD ADOR16
X_1910_ _0572_ _0579_ _0580_ VSS VDD AND201
X_1911_ _0572_ _0579_ _0581_ VDD VSS NOR200
X_1912_ _0580_ _0581_ _0582_ VDD VSS NOR200
X_1913_ _0582_ _0583_ VDD VSS INVR01
X_1914_ _0554_ _0556_ _0583_ _0584_ VDD VSS ADNR01
X_1915_ _0569_ _0583_ _0585_ VSS VDD XNR201
X_1916_ _0585_ _0586_ VDD VSS INVR01
X_1917_ _0568_ _0586_ _0587_ VDD VSS NOR200
X_1918_ _0568_ _0586_ _0588_ VSS VDD XNR201
X_1919_ _0562_ _0564_ _0588_ _0589_ VDD VSS ADNR01
X_1920_ _0588_ _0564_ _0562_ _0590_ VDD VSS AND301
X_1921_ _0589_ _0590_ _0890_[6] VDD VSS NOR200
X_1922_ P12[7] _0565_ MODE[0] _0591_ VSS VDD ORND01
X_1923_ P12[7] _0565_ _0591_ _0592_ VDD VSS ADNR01
X_1924_ _0048_ P12[6] _0592_ _0593_ VDD VSS ADNR01
X_1925_ P10[7] _0570_ _0594_ VSS VDD NND201
X_1926_ P10[7] _0570_ _0595_ VSS VDD OR2101
X_1927_ _0595_ _0594_ MODE[0] _0596_ VSS VDD NND300
X_1928_ _0289_ _0571_ _0597_ VSS VDD NND201
X_1929_ P10[6] _0292_ _0598_ VSS VDD NND201
X_1930_ _0598_ _0597_ _0596_ _0599_ VDD VSS AND301
X_1931_ _0599_ _0600_ VDD VSS INVR01
X_1932_ _0574_ _0577_ _0601_ VSS VDD NND201
X_1933_ P11[5] P11[7] _0602_ VSS VDD NND201
X_1934_ P11[5] P11[7] _0603_ VSS VDD XOR201
X_1935_ _0601_ _0603_ _0604_ VDD VSS NOR200
X_1936_ _0601_ _0603_ _0605_ VSS VDD NND201
X_1937_ _0278_ _0604_ _0606_ VDD VSS NOR200
X_1938_ _0292_ P11[5] _0605_ _0606_ _0437_ P11[4] _0607_ VSS VDD ADOR16
X_1939_ _0600_ _0607_ _0608_ VSS VDD NND201
X_1940_ _0599_ _0607_ _0609_ VSS VDD XNR201
X_1941_ _0580_ _0584_ _0609_ _0610_ VSS VDD ORND01
X_1942_ _0580_ _0584_ _0609_ _0611_ VDD VSS OR3101
X_1943_ _0610_ _0611_ _0612_ VSS VDD NND201
X_1944_ _0593_ _0612_ _0613_ VSS VDD OR2101
X_1945_ _0593_ _0612_ _0614_ VSS VDD XOR201
X_1946_ _0587_ _0589_ _0614_ _0615_ VSS VDD ORND01
X_1947_ _0587_ _0589_ _0614_ _0616_ VDD VSS OR3101
X_1948_ _0615_ _0616_ _0890_[7] VSS VDD AND201
X_1949_ MODE[0] _0565_ P12[7] _0617_ VDD VSS ADNR01
X_1950_ _0617_ _0618_ VDD VSS INVR01
X_1951_ _0602_ _0605_ _0619_ VSS VDD NND201
X_1952_ P11[6] _0619_ _0620_ VSS VDD NND201
X_1953_ P11[6] _0619_ _0278_ _0621_ VDD VSS ADNR01
X_1954_ P11[6] _0619_ _0621_ _0622_ VSS VDD ORND01
X_1955_ P11[5] _0437_ _0623_ VSS VDD NND201
X_1956_ _0622_ _0623_ _0624_ VSS VDD NND201
X_1957_ P11[6] _0292_ _0624_ _0625_ VDD VSS ADNR01
X_1958_ _0290_ _0594_ _0626_ VDD VSS NOR200
X_1959_ _0293_ _0570_ P10[7] _0627_ VDD VSS ADNR01
X_1960_ _0626_ _0627_ _0628_ VSS VDD OR2101
X_1961_ _0625_ _0628_ _0629_ VDD VSS NOR200
X_1962_ _0625_ _0628_ _0630_ VSS VDD XNR201
X_1963_ _0608_ _0610_ _0630_ _0631_ VDD VSS ADNR01
X_1964_ _0630_ _0610_ _0608_ _0632_ VDD VSS AND301
X_1965_ _0631_ _0632_ _0633_ VDD VSS NOR200
X_1966_ _0617_ _0631_ _0632_ _0634_ VDD VSS NOR300
X_1967_ _0618_ _0633_ _0635_ VSS VDD XNR201
X_1968_ _0613_ _0615_ _0635_ _0636_ VDD VSS ADNR01
X_1969_ _0635_ _0615_ _0613_ _0637_ VDD VSS AND301
X_1970_ _0636_ _0637_ _0890_[8] VDD VSS NOR200
X_1971_ _0634_ _0636_ _0638_ VDD VSS NOR200
X_1972_ _0629_ _0631_ _0639_ VSS VDD OR2101
X_1973_ P11[7] _0620_ _0640_ VSS VDD XNR201
X_1974_ _0277_ _0640_ _0641_ VSS VDD NND201
X_1975_ P11[7] _0292_ _0437_ P11[6] _0642_ VDD VSS AOI401
X_1976_ _0293_ _0595_ _0643_ VSS VDD NND201
X_1977_ _0641_ _0642_ _0643_ _0644_ VDD VSS ADNR01
X_1978_ _0643_ _0642_ _0641_ _0645_ VDD VSS AND301
X_1979_ _0644_ _0645_ _0646_ VDD VSS NOR200
X_1980_ _0639_ _0646_ _0647_ VSS VDD XNR201
X_1981_ _0591_ _0647_ _0648_ VSS VDD OR2101
X_1982_ _0591_ _0647_ _0649_ VSS VDD XOR201
X_1983_ _0634_ _0636_ _0649_ _0650_ VSS VDD ORND01
X_1984_ _0638_ _0649_ _0890_[9] VSS VDD XNR201
X_1985_ _0639_ _0644_ _0651_ VDD VSS NOR200
X_1986_ _0645_ _0651_ _0652_ VDD VSS NOR200
X_1987_ MODE[0] P11[7] _0653_ VSS VDD NND201
X_1988_ _0621_ _0653_ _0654_ VDD VSS NOR200
X_1989_ _0643_ _0654_ _0655_ VDD VSS NOR200
X_1990_ _0643_ _0654_ _0656_ VSS VDD XNR201
X_1991_ _0652_ _0656_ _0657_ VSS VDD XNR201
X_1992_ _0591_ _0657_ _0658_ VDD VSS NOR200
X_1993_ _0591_ _0657_ _0659_ VSS VDD XNR201
X_1994_ _0648_ _0650_ _0659_ _0660_ VDD VSS ADNR01
X_1995_ _0659_ _0650_ _0648_ _0661_ VDD VSS AND301
X_1996_ _0660_ _0661_ _0890_[10] VDD VSS NOR200
X_1997_ _0658_ _0660_ _0662_ VDD VSS NOR200
X_1998_ _0651_ _0655_ _0663_ VSS VDD NND201
X_1999_ _0591_ _0663_ _0664_ VSS VDD XOR201
X_2000_ _0662_ _0664_ _0890_[11] VSS VDD XNR201
X_2001_ _0452_ _0456_ _0889_[0] VSS VDD XOR201
X_2002_ P22[0] _0278_ _0665_ VSS VDD NND201
X_2003_ MODE[0] P21[0] _0666_ VSS VDD NND201
X_2004_ MODE[1] P20[0] _0667_ VSS VDD AND201
X_2005_ _0667_ P21[0] MODE[0] _0668_ VSS VDD NND300
X_2006_ P20[0] _0278_ _0669_ VSS VDD NND201
X_2007_ _0666_ _0667_ _0670_ _0669_ VDD VSS MX2101
X_2008_ _0665_ _0670_ _0671_ VDD VSS NOR200
X_2009_ P20[1] _0667_ _0672_ VSS VDD XNR201
X_2010_ _0277_ _0672_ _0673_ VDD VSS NOR200
X_2011_ MODE[0] P21[1] _0674_ VSS VDD AND201
X_2012_ P21[0] _0290_ _0674_ _0675_ VDD VSS ADNR01
X_2013_ P21[0] _0674_ _0675_ _0676_ VDD VSS ADNR01
X_2014_ _0673_ _0676_ _0677_ VSS VDD AND201
X_2015_ _0673_ _0676_ _0678_ VSS VDD XNR201
X_2016_ _0668_ _0678_ _0679_ VDD VSS NOR200
X_2017_ _0668_ _0678_ _0680_ VSS VDD XNR201
X_2018_ MODE[0] P22[0] _0681_ VSS VDD NND201
X_2019_ P22[1] _0681_ _0682_ VSS VDD XOR201
X_2020_ _0277_ _0682_ _0683_ VDD VSS NOR200
X_2021_ _0277_ _0680_ _0682_ _0684_ VDD VSS OR3101
X_2022_ _0680_ _0683_ _0685_ VSS VDD XNR201
X_2023_ _0671_ _0685_ _0686_ VSS VDD NND201
X_2024_ _0671_ _0685_ _0892_[1] VSS VDD XOR201
X_2025_ _0677_ _0679_ _0687_ VDD VSS NOR200
X_2026_ P20[0] P20[1] P20[2] _0688_ VSS VDD ORND01
X_2027_ P20[0] P20[1] P20[2] _0689_ VDD VSS OR3101
X_2028_ MODE[1] _0689_ _0690_ VSS VDD NND201
X_2029_ _0689_ _0688_ MODE[1] _0691_ VSS VDD NND300
X_2030_ P20[2] _0292_ _0692_ VSS VDD NND201
X_2031_ _0691_ _0692_ _0693_ VSS VDD NND201
X_2032_ P21[1] _0292_ _0694_ VSS VDD NND201
X_2033_ P21[0] P21[1] P21[2] _0695_ VSS VDD ORND01
X_2034_ P21[0] P21[1] P21[2] _0696_ VDD VSS OR3101
X_2035_ _0696_ _0695_ MODE[0] _0697_ VSS VDD NND300
X_2036_ _0694_ _0697_ _0698_ VSS VDD NND201
X_2037_ _0693_ _0698_ _0699_ VSS VDD NND201
X_2038_ _0693_ _0698_ _0700_ VSS VDD XOR201
X_2039_ _0677_ _0679_ _0700_ _0701_ VSS VDD ORND01
X_2040_ _0687_ _0700_ _0702_ VSS VDD XNR201
X_2041_ P22[0] P22[1] _0703_ VSS VDD OR2101
X_2042_ MODE[0] _0703_ _0704_ VSS VDD NND201
X_2043_ P22[2] _0704_ _0705_ VSS VDD XNR201
X_2044_ _0705_ _0702_ _0278_ _0706_ VDD VSS AND301
X_2045_ _0278_ _0705_ _0702_ _0707_ VDD VSS ADNR01
X_2046_ _0706_ _0707_ _0708_ VSS VDD OR2101
X_2047_ _0684_ _0686_ _0708_ _0709_ VDD VSS ADNR01
X_2048_ _0708_ _0686_ _0684_ _0710_ VDD VSS AND301
X_2049_ _0709_ _0710_ _0892_[2] VDD VSS NOR200
X_2050_ P22[2] _0703_ _0711_ VSS VDD OR2101
X_2051_ MODE[0] _0711_ _0712_ VSS VDD NND201
X_2052_ P22[3] _0712_ _0713_ VSS VDD XOR201
X_2053_ _0277_ _0713_ _0714_ VDD VSS NOR200
X_2054_ _0699_ _0701_ _0715_ VSS VDD NND201
X_2055_ P21[2] _0292_ _0716_ VSS VDD NND201
X_2056_ P21[3] _0696_ _0717_ VSS VDD OR2101
X_2057_ P21[3] _0696_ _0048_ _0718_ VDD VSS ADNR01
X_2058_ _0717_ _0718_ _0719_ VSS VDD NND201
X_2059_ _0716_ _0719_ _0720_ VSS VDD NND201
X_2060_ P20[3] _0278_ _0721_ VSS VDD NND201
X_2061_ _0690_ P20[3] _0722_ _0721_ VDD VSS MX2101
X_2062_ _0716_ _0719_ _0722_ _0723_ VDD VSS ADNR01
X_2063_ _0720_ _0722_ _0724_ VSS VDD XNR201
X_2064_ _0715_ _0724_ _0725_ VSS VDD XOR201
X_2065_ _0714_ _0725_ _0726_ VSS VDD NND201
X_2066_ _0714_ _0725_ _0727_ VSS VDD XOR201
X_2067_ _0706_ _0709_ _0727_ _0728_ VSS VDD ORND01
X_2068_ _0706_ _0709_ _0727_ _0729_ VDD VSS OR3101
X_2069_ _0728_ _0729_ _0892_[3] VSS VDD AND201
X_2070_ _0715_ _0724_ _0723_ _0730_ VDD VSS ADNR01
X_2071_ P20[3] _0689_ _0731_ VSS VDD OR2101
X_2072_ P20[4] _0731_ MODE[1] _0732_ VSS VDD ORND01
X_2073_ P20[4] _0731_ _0732_ _0733_ VDD VSS ADNR01
X_2074_ P20[4] _0292_ _0733_ _0734_ VDD VSS ADNR01
X_2075_ _0734_ _0735_ VDD VSS INVR01
X_2076_ P21[3] _0292_ _0736_ VSS VDD NND201
X_2077_ P21[4] _0717_ _0737_ VSS VDD OR2101
X_2078_ P21[4] _0717_ _0048_ _0738_ VDD VSS ADNR01
X_2079_ _0737_ _0738_ _0739_ VSS VDD NND201
X_2080_ _0736_ _0739_ _0740_ VSS VDD NND201
X_2081_ _0735_ _0740_ _0741_ VSS VDD XNR201
X_2082_ _0730_ _0741_ _0742_ VDD VSS NOR200
X_2083_ _0730_ _0741_ _0743_ VSS VDD XNR201
X_2084_ P22[3] _0711_ _0744_ VSS VDD OR2101
X_2085_ MODE[0] _0744_ P22[4] _0745_ VDD VSS ADNR01
X_2086_ _0744_ P22[4] MODE[0] _0746_ VSS VDD NND300
X_2087_ _0278_ _0746_ _0747_ VSS VDD NND201
X_2088_ _0745_ _0747_ _0748_ VDD VSS NOR200
X_2089_ _0743_ _0745_ _0747_ _0749_ VDD VSS NOR300
X_2090_ _0743_ _0748_ _0750_ VSS VDD XOR201
X_2091_ _0726_ _0728_ _0750_ _0751_ VDD VSS ADNR01
X_2092_ _0750_ _0728_ _0726_ _0752_ VDD VSS AND301
X_2093_ _0751_ _0752_ _0892_[4] VDD VSS NOR200
X_2094_ _0749_ _0751_ _0753_ VDD VSS NOR200
X_2095_ P22[4] _0744_ _0754_ VSS VDD OR2101
X_2096_ MODE[0] _0754_ _0755_ VSS VDD NND201
X_2097_ P22[5] _0755_ _0756_ VSS VDD XOR201
X_2098_ _0277_ _0756_ _0757_ VDD VSS NOR200
X_2099_ _0735_ _0740_ _0742_ _0758_ VDD VSS ADNR01
X_2100_ P21[5] _0737_ _0759_ VSS VDD OR2101
X_2101_ MODE[0] _0759_ _0760_ VSS VDD NND201
X_2102_ P21[5] _0737_ _0760_ _0761_ VDD VSS ADNR01
X_2103_ P21[4] _0292_ _0761_ _0762_ VDD VSS ADNR01
X_2104_ P20[5] _0278_ _0763_ VSS VDD NND201
X_2105_ _0732_ P20[5] _0764_ _0763_ VDD VSS MX2101
X_2106_ _0762_ _0764_ _0765_ VDD VSS NOR200
X_2107_ _0762_ _0764_ _0766_ VSS VDD XOR201
X_2108_ _0766_ _0767_ VDD VSS INVR01
X_2109_ _0758_ _0767_ _0768_ VDD VSS NOR200
X_2110_ _0758_ _0766_ _0769_ VSS VDD XNR201
X_2111_ _0757_ _0769_ _0770_ VSS VDD NND201
X_2112_ _0757_ _0769_ _0771_ VSS VDD XOR201
X_2113_ _0749_ _0751_ _0771_ _0772_ VSS VDD ORND01
X_2114_ _0753_ _0771_ _0892_[5] VSS VDD XNR201
X_2115_ _0765_ _0768_ _0773_ VDD VSS NOR200
X_2116_ P20[4] P20[5] _0731_ _0774_ VDD VSS OR3101
X_2117_ P20[6] _0774_ _0775_ VSS VDD AND201
X_2118_ P20[6] _0774_ MODE[1] _0776_ VSS VDD ORND01
X_2119_ P20[6] _0292_ _0777_ VSS VDD NND201
X_2120_ _0775_ _0776_ _0777_ _0778_ VSS VDD ORND01
X_2121_ P21[5] _0292_ _0779_ VSS VDD NND201
X_2122_ P21[6] _0759_ _0780_ VSS VDD NND201
X_2123_ P21[6] _0759_ _0781_ VSS VDD OR2101
X_2124_ MODE[0] _0781_ _0782_ VSS VDD AND201
X_2125_ _0780_ _0782_ _0783_ VSS VDD NND201
X_2126_ _0779_ _0783_ _0784_ VSS VDD NND201
X_2127_ _0778_ _0784_ _0785_ VSS VDD NND201
X_2128_ _0778_ _0784_ _0786_ VSS VDD XOR201
X_2129_ _0765_ _0768_ _0786_ _0787_ VSS VDD ORND01
X_2130_ _0773_ _0786_ _0788_ VSS VDD XNR201
X_2131_ P22[5] _0754_ _0789_ VSS VDD OR2101
X_2132_ MODE[0] _0789_ _0790_ VSS VDD NND201
X_2133_ P22[6] _0790_ _0791_ VSS VDD XOR201
X_2134_ _0277_ _0791_ _0792_ VDD VSS NOR200
X_2135_ _0788_ _0792_ _0793_ VSS VDD XNR201
X_2136_ _0770_ _0772_ _0793_ _0794_ VDD VSS ADNR01
X_2137_ _0793_ _0772_ _0770_ _0795_ VDD VSS AND301
X_2138_ _0794_ _0795_ _0892_[6] VDD VSS NOR200
X_2139_ _0788_ _0792_ _0794_ _0796_ VDD VSS ADNR01
X_2140_ P22[6] _0789_ _0797_ VSS VDD OR2101
X_2141_ MODE[0] _0797_ _0798_ VSS VDD NND201
X_2142_ P22[7] _0798_ _0799_ VSS VDD XOR201
X_2143_ _0277_ _0799_ _0800_ VDD VSS NOR200
X_2144_ P21[7] _0781_ _0801_ VSS VDD NND201
X_2145_ P21[7] _0781_ _0802_ VDD VSS NOR200
X_2146_ _0048_ _0802_ _0803_ VDD VSS NOR200
X_2147_ _0801_ _0803_ _0804_ VSS VDD NND201
X_2148_ P21[6] _0292_ _0805_ VSS VDD NND201
X_2149_ _0804_ _0805_ _0806_ VSS VDD NND201
X_2150_ _0806_ _0807_ VDD VSS INVR01
X_2151_ MODE[1] P20[7] _0808_ VSS VDD NND201
X_2152_ P20[7] _0278_ _0809_ VSS VDD NND201
X_2153_ _0776_ P20[7] _0810_ _0809_ VDD VSS MX2101
X_2154_ _0807_ _0810_ _0811_ VDD VSS NOR200
X_2155_ _0807_ _0810_ _0812_ VSS VDD XNR201
X_2156_ _0785_ _0787_ _0812_ _0813_ VDD VSS ADNR01
X_2157_ _0812_ _0787_ _0785_ _0814_ VDD VSS AND301
X_2158_ _0813_ _0814_ _0815_ VDD VSS NOR200
X_2159_ _0800_ _0815_ _0816_ VSS VDD NND201
X_2160_ _0800_ _0815_ _0817_ VSS VDD XNR201
X_2161_ _0796_ _0817_ _0818_ VSS VDD OR2101
X_2162_ _0796_ _0817_ _0892_[7] VSS VDD XOR201
X_2163_ P22[7] _0797_ _0437_ _0819_ VSS VDD ORND01
X_2164_ _0811_ _0813_ _0820_ VDD VSS NOR200
X_2165_ _0776_ _0808_ _0821_ VSS VDD NND201
X_2166_ P21[7] _0782_ _0290_ _0822_ VSS VDD ORND01
X_2167_ _0821_ _0822_ _0823_ VSS VDD XOR201
X_2168_ _0820_ _0823_ _0824_ VSS VDD XNR201
X_2169_ _0819_ _0824_ _0825_ VDD VSS NOR200
X_2170_ _0819_ _0824_ _0826_ VSS VDD XNR201
X_2171_ _0816_ _0818_ _0826_ _0827_ VDD VSS ADNR01
X_2172_ _0826_ _0818_ _0816_ _0828_ VDD VSS AND301
X_2173_ _0827_ _0828_ _0892_[8] VDD VSS NOR200
X_2174_ _0803_ _0821_ _0829_ VDD VSS NOR200
X_2175_ _0820_ _0823_ _0829_ _0830_ VSS VDD ORND01
X_2176_ _0819_ _0830_ _0045_ VSS VDD XNR201
X_2177_ _0825_ _0827_ _0045_ _0046_ VDD VSS NOR300
X_2178_ _0827_ _0045_ _0046_ _0892_[9] VDD VSS ADNR01
X_2179_ _0819_ _0829_ _0045_ _0827_ _0892_[10] VDD VSS AOI401
X_2180_ _0665_ _0670_ _0891_[0] VSS VDD XOR201
X_2181_ _0438_ _0448_ _0450_ _0446_ _0888_[11] VDD VSS AOI401
X_2182_ _0438_ _0448_ _0450_ _0446_ _0888_[12] VDD VSS AOI401
X_2183_ _0438_ _0448_ _0450_ _0446_ _0888_[13] VDD VSS AOI401
X_2184_ _0438_ _0448_ _0450_ _0446_ _0888_[14] VDD VSS AOI401
X_2185_ _0662_ _0664_ _0890_[12] VSS VDD XNR201
X_2186_ _0662_ _0664_ _0890_[13] VSS VDD XNR201
X_2187_ _0662_ _0664_ _0890_[14] VSS VDD XNR201
X_2188_ _0819_ _0829_ _0045_ _0827_ _0892_[11] VDD VSS AOI401
X_2189_ _0819_ _0829_ _0045_ _0827_ _0892_[12] VDD VSS AOI401
X_2190_ _0819_ _0829_ _0045_ _0827_ _0892_[13] VDD VSS AOI401
X_2191_ _0819_ _0829_ _0045_ _0827_ _0892_[14] VDD VSS AOI401
X_2192_ CLKNET_5_22__LEAF_CLK _0043_[0] RST_N _0832_ PIXEL_OUT[0] VSS VDD DFCL11
X_2193_ CLKNET_5_22__LEAF_CLK _0043_[1] RST_N _0833_ PIXEL_OUT[1] VSS VDD DFCL11
X_2194_ CLKNET_5_22__LEAF_CLK _0043_[2] RST_N _0834_ PIXEL_OUT[2] VSS VDD DFCL11
X_2195_ CLKNET_5_29__LEAF_CLK _0043_[3] RST_N _0835_ PIXEL_OUT[3] VSS VDD DFCL11
X_2196_ CLKNET_5_23__LEAF_CLK _0043_[4] RST_N _0836_ PIXEL_OUT[4] VSS VDD DFCL11
X_2197_ CLKNET_5_23__LEAF_CLK _0043_[5] RST_N _0837_ PIXEL_OUT[5] VSS VDD DFCL11
X_2198_ CLKNET_5_23__LEAF_CLK _0043_[6] RST_N _0838_ PIXEL_OUT[6] VSS VDD DFCL11
X_2199_ CLKNET_5_22__LEAF_CLK _0043_[7] RST_N _0839_ PIXEL_OUT[7] VSS VDD DFCL11
X_2200_ CLKNET_5_29__LEAF_CLK \U_CON RST_N _0840_ VALID_OUT VSS VDD DFCL11
X_2201_ CLKNET_5_27__LEAF_CLK _0887_[0] RST_N _0841_ \U_CON VSS VDD DFCL11
X_2202_ CLKNET_5_26__LEAF_CLK _0888_[1] RST_N _0842_ \U_CON VSS VDD DFCL11
X_2203_ CLKNET_5_13__LEAF_CLK _0888_[2] RST_N _0843_ \U_CON VSS VDD DFCL11
X_2204_ CLKNET_5_7__LEAF_CLK _0888_[3] RST_N _0844_ \U_CON VSS VDD DFCL11
X_2205_ CLKNET_5_7__LEAF_CLK _0888_[4] RST_N _0845_ \U_CON VSS VDD DFCL11
X_2206_ CLKNET_5_18__LEAF_CLK _0888_[5] RST_N _0846_ \U_CON VSS VDD DFCL11
X_2207_ CLKNET_5_16__LEAF_CLK _0888_[6] RST_N _0847_ \U_CON VSS VDD DFCL11
X_2208_ CLKNET_5_4__LEAF_CLK _0888_[7] RST_N _0848_ \U_CON VSS VDD DFCL11
X_2209_ CLKNET_5_4__LEAF_CLK _0888_[8] RST_N _0849_ \U_CON VSS VDD DFCL11
X_2210_ CLKNET_5_5__LEAF_CLK _0888_[9] RST_N _0850_ \U_CON VSS VDD DFCL11
X_2211_ CLKNET_5_16__LEAF_CLK _0888_[10] RST_N _0851_ \U_CON VSS VDD DFCL11
X_2212_ CLKNET_5_17__LEAF_CLK _0888_[11] RST_N _0852_ \U_CON VSS VDD DFCL11
X_2213_ CLKNET_5_16__LEAF_CLK _0888_[12] RST_N _0853_ \U_CON VSS VDD DFCL11
X_2214_ CLKNET_5_16__LEAF_CLK _0888_[13] RST_N _0854_ \U_CON VSS VDD DFCL11
X_2215_ CLKNET_5_20__LEAF_CLK _0888_[14] RST_N _0855_ \U_CON VSS VDD DFCL11
X_2216_ CLKNET_5_26__LEAF_CLK _0889_[0] RST_N _0856_ \U_CON VSS VDD DFCL11
X_2217_ CLKNET_5_26__LEAF_CLK _0890_[1] RST_N _0857_ \U_CON VSS VDD DFCL11
X_2218_ CLKNET_5_19__LEAF_CLK _0890_[2] RST_N _0858_ \U_CON VSS VDD DFCL11
X_2219_ CLKNET_5_13__LEAF_CLK _0890_[3] RST_N _0859_ \U_CON VSS VDD DFCL11
X_2220_ CLKNET_5_7__LEAF_CLK _0890_[4] RST_N _0860_ \U_CON VSS VDD DFCL11
X_2221_ CLKNET_5_18__LEAF_CLK _0890_[5] RST_N _0861_ \U_CON VSS VDD DFCL11
X_2222_ CLKNET_5_16__LEAF_CLK _0890_[6] RST_N _0862_ \U_CON VSS VDD DFCL11
X_2223_ CLKNET_5_16__LEAF_CLK _0890_[7] RST_N _0863_ \U_CON VSS VDD DFCL11
X_2224_ CLKNET_5_17__LEAF_CLK _0890_[8] RST_N _0864_ \U_CON VSS VDD DFCL11
X_2225_ CLKNET_5_17__LEAF_CLK _0890_[9] RST_N _0865_ \U_CON VSS VDD DFCL11
X_2226_ CLKNET_5_16__LEAF_CLK _0890_[10] RST_N _0866_ \U_CON VSS VDD DFCL11
X_2227_ CLKNET_5_17__LEAF_CLK _0890_[11] RST_N _0867_ \U_CON VSS VDD DFCL11
X_2228_ CLKNET_5_17__LEAF_CLK _0890_[12] RST_N _0868_ \U_CON VSS VDD DFCL11
X_2229_ CLKNET_5_20__LEAF_CLK _0890_[13] RST_N _0869_ \U_CON VSS VDD DFCL11
X_2230_ CLKNET_5_20__LEAF_CLK _0890_[14] RST_N _0870_ \U_CON VSS VDD DFCL11
X_2231_ CLKNET_5_27__LEAF_CLK _0891_[0] RST_N _0871_ \U_CON VSS VDD DFCL11
X_2232_ CLKNET_5_29__LEAF_CLK _0892_[1] RST_N _0872_ \U_CON VSS VDD DFCL11
X_2233_ CLKNET_5_22__LEAF_CLK _0892_[2] RST_N _0873_ \U_CON VSS VDD DFCL11
X_2234_ CLKNET_5_22__LEAF_CLK _0892_[3] RST_N _0874_ \U_CON VSS VDD DFCL11
X_2235_ CLKNET_5_22__LEAF_CLK _0892_[4] RST_N _0875_ \U_CON VSS VDD DFCL11
X_2236_ CLKNET_5_23__LEAF_CLK _0892_[5] RST_N _0876_ \U_CON VSS VDD DFCL11
X_2237_ CLKNET_5_23__LEAF_CLK _0892_[6] RST_N _0877_ \U_CON VSS VDD DFCL11
X_2238_ CLKNET_5_23__LEAF_CLK _0892_[7] RST_N _0878_ \U_CON VSS VDD DFCL11
X_2239_ CLKNET_5_23__LEAF_CLK _0892_[8] RST_N _0879_ \U_CON VSS VDD DFCL11
X_2240_ CLKNET_5_20__LEAF_CLK _0892_[9] RST_N _0880_ \U_CON VSS VDD DFCL11
X_2241_ CLKNET_5_20__LEAF_CLK _0892_[10] RST_N _0881_ \U_CON VSS VDD DFCL11
X_2242_ CLKNET_5_20__LEAF_CLK _0892_[11] RST_N _0882_ \U_CON VSS VDD DFCL11
X_2243_ CLKNET_5_21__LEAF_CLK _0892_[12] RST_N _0883_ \U_CON VSS VDD DFCL11
X_2244_ CLKNET_5_21__LEAF_CLK _0892_[13] RST_N _0884_ \U_CON VSS VDD DFCL11
X_2245_ CLKNET_5_21__LEAF_CLK _0892_[14] RST_N _0885_ \U_CON VSS VDD DFCL11
X_2246_ CLKNET_5_23__LEAF_CLK MODE[0] RST_N _0044_ \U_CON VSS VDD DFCL11
X_2247_ CLKNET_5_21__LEAF_CLK MODE[1] RST_N _0886_ \U_CON VSS VDD DFCL11
X_2248_ CLKNET_5_29__LEAF_CLK CONV_VALID_IN RST_N _0831_ \U_CON VSS VDD DFCL11
X_2249_ VALID_IN P21[0] _0893_ P22[0] VDD VSS MX2101
X_2250_ VALID_IN P21[1] _0894_ P22[1] VDD VSS MX2101
X_2251_ VALID_IN P21[2] _0895_ P22[2] VDD VSS MX2101
X_2252_ VALID_IN P21[3] _0896_ P22[3] VDD VSS MX2101
X_2253_ VALID_IN P21[4] _0897_ P22[4] VDD VSS MX2101
X_2254_ VALID_IN P21[5] _0898_ P22[5] VDD VSS MX2101
X_2255_ VALID_IN P21[6] _0899_ P22[6] VDD VSS MX2101
X_2256_ VALID_IN P21[7] _0900_ P22[7] VDD VSS MX2101
X_2257_ VALID_IN P10[0] _0901_ P11[0] VDD VSS MX2101
X_2258_ VALID_IN P10[1] _0902_ P11[1] VDD VSS MX2101
X_2259_ VALID_IN P10[2] _0903_ P11[2] VDD VSS MX2101
X_2260_ VALID_IN P10[3] _0904_ P11[3] VDD VSS MX2101
X_2261_ VALID_IN P10[4] _0905_ P11[4] VDD VSS MX2101
X_2262_ VALID_IN P10[5] _0906_ P11[5] VDD VSS MX2101
X_2263_ VALID_IN P10[6] _0907_ P11[6] VDD VSS MX2101
X_2264_ VALID_IN P10[7] _0908_ P11[7] VDD VSS MX2101
X_2265_ VALID_IN P20[0] _0909_ P21[0] VDD VSS MX2101
X_2266_ VALID_IN P20[1] _0910_ P21[1] VDD VSS MX2101
X_2267_ VALID_IN P20[2] _0911_ P21[2] VDD VSS MX2101
X_2268_ VALID_IN P20[3] _0912_ P21[3] VDD VSS MX2101
X_2269_ VALID_IN P20[4] _0913_ P21[4] VDD VSS MX2101
X_2270_ VALID_IN P20[5] _0914_ P21[5] VDD VSS MX2101
X_2271_ VALID_IN P20[6] _0915_ P21[6] VDD VSS MX2101
X_2272_ VALID_IN P20[7] _0916_ P21[7] VDD VSS MX2101
X_2273_ VALID_IN P12[0] _0917_ \U_WINDO VDD VSS MX2101
X_2274_ VALID_IN P12[1] _0918_ \U_WINDO VDD VSS MX2101
X_2275_ VALID_IN P12[2] _0919_ \U_WINDO VDD VSS MX2101
X_2276_ VALID_IN P12[3] _0920_ \U_WINDO VDD VSS MX2101
X_2277_ VALID_IN P12[4] _0921_ \U_WINDO VDD VSS MX2101
X_2278_ VALID_IN P12[5] _0922_ \U_WINDO VDD VSS MX2101
X_2279_ VALID_IN P12[6] _0923_ \U_WINDO VDD VSS MX2101
X_2280_ VALID_IN P12[7] _0924_ \U_WINDO VDD VSS MX2101
X_2281_ VALID_IN P01[0] _0925_ P02[0] VDD VSS MX2101
X_2282_ VALID_IN P01[1] _0926_ P02[1] VDD VSS MX2101
X_2283_ VALID_IN P01[2] _0927_ P02[2] VDD VSS MX2101
X_2284_ VALID_IN P01[3] _0928_ P02[3] VDD VSS MX2101
X_2285_ VALID_IN P01[4] _0929_ P02[4] VDD VSS MX2101
X_2286_ VALID_IN P01[5] _0930_ P02[5] VDD VSS MX2101
X_2287_ VALID_IN P01[6] _0931_ P02[6] VDD VSS MX2101
X_2288_ VALID_IN P01[7] _0932_ P02[7] VDD VSS MX2101
X_2289_ VALID_IN P02[0] _0933_ \U_WINDO VDD VSS MX2101
X_2290_ VALID_IN P02[1] _0934_ \U_WINDO VDD VSS MX2101
X_2291_ VALID_IN P02[2] _0935_ \U_WINDO VDD VSS MX2101
X_2292_ VALID_IN P02[3] _0936_ \U_WINDO VDD VSS MX2101
X_2293_ VALID_IN P02[4] _0937_ \U_WINDO VDD VSS MX2101
X_2294_ VALID_IN P02[5] _0938_ \U_WINDO VDD VSS MX2101
X_2295_ VALID_IN P02[6] _0939_ \U_WINDO VDD VSS MX2101
X_2296_ VALID_IN P02[7] _0940_ \U_WINDO VDD VSS MX2101
X_2297_ VALID_IN P11[0] _0941_ P12[0] VDD VSS MX2101
X_2298_ VALID_IN P11[1] _0942_ P12[1] VDD VSS MX2101
X_2299_ VALID_IN P11[2] _0943_ P12[2] VDD VSS MX2101
X_2300_ VALID_IN P11[3] _0944_ P12[3] VDD VSS MX2101
X_2301_ VALID_IN P11[4] _0945_ P12[4] VDD VSS MX2101
X_2302_ VALID_IN P11[5] _0946_ P12[5] VDD VSS MX2101
X_2303_ VALID_IN P11[6] _0947_ P12[6] VDD VSS MX2101
X_2304_ VALID_IN P11[7] _0948_ P12[7] VDD VSS MX2101
X_2305_ VALID_IN P22[0] _0949_ PIXEL_IN[0] VDD VSS MX2101
X_2306_ VALID_IN P22[1] _0950_ PIXEL_IN[1] VDD VSS MX2101
X_2307_ VALID_IN P22[2] _0951_ PIXEL_IN[2] VDD VSS MX2101
X_2308_ VALID_IN P22[3] _0952_ PIXEL_IN[3] VDD VSS MX2101
X_2309_ VALID_IN P22[4] _0953_ PIXEL_IN[4] VDD VSS MX2101
X_2310_ VALID_IN P22[5] _0954_ PIXEL_IN[5] VDD VSS MX2101
X_2311_ VALID_IN P22[6] _0955_ PIXEL_IN[6] VDD VSS MX2101
X_2312_ VALID_IN P22[7] _0956_ PIXEL_IN[7] VDD VSS MX2101
X_2313_ VALID_IN P00[0] _0957_ P01[0] VDD VSS MX2101
X_2314_ VALID_IN P00[1] _0958_ P01[1] VDD VSS MX2101
X_2315_ VALID_IN P00[2] _0959_ P01[2] VDD VSS MX2101
X_2316_ VALID_IN P00[3] _0960_ P01[3] VDD VSS MX2101
X_2317_ VALID_IN P00[4] _0961_ P01[4] VDD VSS MX2101
X_2318_ VALID_IN P00[5] _0962_ P01[5] VDD VSS MX2101
X_2319_ VALID_IN P00[6] _0963_ P01[6] VDD VSS MX2101
X_2320_ VALID_IN P00[7] _0964_ P01[7] VDD VSS MX2101
X_2321_ CLKNET_5_22__LEAF_CLK _0893_ RST_N _1036_ P21[0] VSS VDD DFCL11
X_2322_ CLKNET_5_25__LEAF_CLK _0894_ RST_N _1035_ P21[1] VSS VDD DFCL11
X_2323_ CLKNET_5_19__LEAF_CLK _0895_ RST_N _1034_ P21[2] VSS VDD DFCL11
X_2324_ CLKNET_5_19__LEAF_CLK _0896_ RST_N _1033_ P21[3] VSS VDD DFCL11
X_2325_ CLKNET_5_18__LEAF_CLK _0897_ RST_N _1032_ P21[4] VSS VDD DFCL11
X_2326_ CLKNET_5_18__LEAF_CLK _0898_ RST_N _1031_ P21[5] VSS VDD DFCL11
X_2327_ CLKNET_5_17__LEAF_CLK _0899_ RST_N _1030_ P21[6] VSS VDD DFCL11
X_2328_ CLKNET_5_17__LEAF_CLK _0900_ RST_N _1029_ P21[7] VSS VDD DFCL11
X_2329_ CLKNET_5_15__LEAF_CLK _0901_ RST_N _1028_ P10[0] VSS VDD DFCL11
X_2330_ CLKNET_5_7__LEAF_CLK _0902_ RST_N _1027_ P10[1] VSS VDD DFCL11
X_2331_ CLKNET_5_7__LEAF_CLK _0903_ RST_N _1026_ P10[2] VSS VDD DFCL11
X_2332_ CLKNET_5_6__LEAF_CLK _0904_ RST_N _1025_ P10[3] VSS VDD DFCL11
X_2333_ CLKNET_5_6__LEAF_CLK _0905_ RST_N _1024_ P10[4] VSS VDD DFCL11
X_2334_ CLKNET_5_6__LEAF_CLK _0906_ RST_N _1023_ P10[5] VSS VDD DFCL11
X_2335_ CLKNET_5_6__LEAF_CLK _0907_ RST_N _1022_ P10[6] VSS VDD DFCL11
X_2336_ CLKNET_5_4__LEAF_CLK _0908_ RST_N _1021_ P10[7] VSS VDD DFCL11
X_2337_ CLKNET_5_19__LEAF_CLK _0909_ RST_N _1020_ P20[0] VSS VDD DFCL11
X_2338_ CLKNET_5_19__LEAF_CLK _0910_ RST_N _1019_ P20[1] VSS VDD DFCL11
X_2339_ CLKNET_5_19__LEAF_CLK _0911_ RST_N _1018_ P20[2] VSS VDD DFCL11
X_2340_ CLKNET_5_19__LEAF_CLK _0912_ RST_N _1017_ P20[3] VSS VDD DFCL11
X_2341_ CLKNET_5_18__LEAF_CLK _0913_ RST_N _1016_ P20[4] VSS VDD DFCL11
X_2342_ CLKNET_5_18__LEAF_CLK _0914_ RST_N _1015_ P20[5] VSS VDD DFCL11
X_2343_ CLKNET_5_18__LEAF_CLK _0915_ RST_N _1014_ P20[6] VSS VDD DFCL11
X_2344_ CLKNET_5_17__LEAF_CLK _0916_ RST_N _1013_ P20[7] VSS VDD DFCL11
X_2345_ CLKNET_5_12__LEAF_CLK _0917_ RST_N _1012_ P12[0] VSS VDD DFCL11
X_2346_ CLKNET_5_12__LEAF_CLK _0918_ RST_N _1011_ P12[1] VSS VDD DFCL11
X_2347_ CLKNET_5_12__LEAF_CLK _0919_ RST_N _1010_ P12[2] VSS VDD DFCL11
X_2348_ CLKNET_5_12__LEAF_CLK _0920_ RST_N _1009_ P12[3] VSS VDD DFCL11
X_2349_ CLKNET_5_13__LEAF_CLK _0921_ RST_N _1008_ P12[4] VSS VDD DFCL11
X_2350_ CLKNET_5_6__LEAF_CLK _0922_ RST_N _1007_ P12[5] VSS VDD DFCL11
X_2351_ CLKNET_5_5__LEAF_CLK _0923_ RST_N _1006_ P12[6] VSS VDD DFCL11
X_2352_ CLKNET_5_0__LEAF_CLK _0924_ RST_N _1005_ P12[7] VSS VDD DFCL11
X_2353_ CLKNET_5_14__LEAF_CLK _0925_ RST_N _1004_ P01[0] VSS VDD DFCL11
X_2354_ CLKNET_5_9__LEAF_CLK _0926_ RST_N _1003_ P01[1] VSS VDD DFCL11
X_2355_ CLKNET_5_8__LEAF_CLK _0927_ RST_N _1002_ P01[2] VSS VDD DFCL11
X_2356_ CLKNET_5_3__LEAF_CLK _0928_ RST_N _1001_ P01[3] VSS VDD DFCL11
X_2357_ CLKNET_5_2__LEAF_CLK _0929_ RST_N _1000_ P01[4] VSS VDD DFCL11
X_2358_ CLKNET_5_4__LEAF_CLK _0930_ RST_N _0999_ P01[5] VSS VDD DFCL11
X_2359_ CLKNET_5_2__LEAF_CLK _0931_ RST_N _0998_ P01[6] VSS VDD DFCL11
X_2360_ CLKNET_5_0__LEAF_CLK _0932_ RST_N _0997_ P01[7] VSS VDD DFCL11
X_2361_ CLKNET_5_14__LEAF_CLK _0933_ RST_N _0996_ P02[0] VSS VDD DFCL11
X_2362_ CLKNET_5_9__LEAF_CLK _0934_ RST_N _0995_ P02[1] VSS VDD DFCL11
X_2363_ CLKNET_5_9__LEAF_CLK _0935_ RST_N _0994_ P02[2] VSS VDD DFCL11
X_2364_ CLKNET_5_8__LEAF_CLK _0936_ RST_N _0993_ P02[3] VSS VDD DFCL11
X_2365_ CLKNET_5_3__LEAF_CLK _0937_ RST_N _0992_ P02[4] VSS VDD DFCL11
X_2366_ CLKNET_5_4__LEAF_CLK _0938_ RST_N _0991_ P02[5] VSS VDD DFCL11
X_2367_ CLKNET_5_1__LEAF_CLK _0939_ RST_N _0990_ P02[6] VSS VDD DFCL11
X_2368_ CLKNET_5_1__LEAF_CLK _0940_ RST_N _0989_ P02[7] VSS VDD DFCL11
X_2369_ CLKNET_5_13__LEAF_CLK _0941_ RST_N _0988_ P11[0] VSS VDD DFCL11
X_2370_ CLKNET_5_12__LEAF_CLK _0942_ RST_N _0987_ P11[1] VSS VDD DFCL11
X_2371_ CLKNET_5_7__LEAF_CLK _0943_ RST_N _0986_ P11[2] VSS VDD DFCL11
X_2372_ CLKNET_5_7__LEAF_CLK _0944_ RST_N _0985_ P11[3] VSS VDD DFCL11
X_2373_ CLKNET_5_7__LEAF_CLK _0945_ RST_N _0984_ P11[4] VSS VDD DFCL11
X_2374_ CLKNET_5_6__LEAF_CLK _0946_ RST_N _0983_ P11[5] VSS VDD DFCL11
X_2375_ CLKNET_5_5__LEAF_CLK _0947_ RST_N _0982_ P11[6] VSS VDD DFCL11
X_2376_ CLKNET_5_4__LEAF_CLK _0948_ RST_N _0981_ P11[7] VSS VDD DFCL11
X_2377_ CLKNET_5_27__LEAF_CLK _0949_ RST_N _0980_ P22[0] VSS VDD DFCL11
X_2378_ CLKNET_5_27__LEAF_CLK _0950_ RST_N _0979_ P22[1] VSS VDD DFCL11
X_2379_ CLKNET_5_29__LEAF_CLK _0951_ RST_N _0978_ P22[2] VSS VDD DFCL11
X_2380_ CLKNET_5_22__LEAF_CLK _0952_ RST_N _0977_ P22[3] VSS VDD DFCL11
X_2381_ CLKNET_5_19__LEAF_CLK _0953_ RST_N _0976_ P22[4] VSS VDD DFCL11
X_2382_ CLKNET_5_18__LEAF_CLK _0954_ RST_N _0975_ P22[5] VSS VDD DFCL11
X_2383_ CLKNET_5_21__LEAF_CLK _0955_ RST_N _0974_ P22[6] VSS VDD DFCL11
X_2384_ CLKNET_5_16__LEAF_CLK _0956_ RST_N _0973_ P22[7] VSS VDD DFCL11
X_2385_ CLKNET_5_9__LEAF_CLK _0957_ RST_N _0972_ P00[0] VSS VDD DFCL11
X_2386_ CLKNET_5_8__LEAF_CLK _0958_ RST_N _0971_ P00[1] VSS VDD DFCL11
X_2387_ CLKNET_5_8__LEAF_CLK _0959_ RST_N _0970_ P00[2] VSS VDD DFCL11
X_2388_ CLKNET_5_3__LEAF_CLK _0960_ RST_N _0969_ P00[3] VSS VDD DFCL11
X_2389_ CLKNET_5_6__LEAF_CLK _0961_ RST_N _0968_ P00[4] VSS VDD DFCL11
X_2390_ CLKNET_5_6__LEAF_CLK _0962_ RST_N _0967_ P00[5] VSS VDD DFCL11
X_2391_ CLKNET_5_2__LEAF_CLK _0963_ RST_N _0966_ P00[6] VSS VDD DFCL11
X_2392_ CLKNET_5_0__LEAF_CLK _0964_ RST_N _0965_ P00[7] VSS VDD DFCL11
X_2393_ VALID_IN \U_WINDO _1037_ \U_WINDO VDD VSS MX2101
X_2394_ VALID_IN \U_WINDO _1038_ \U_WINDO VDD VSS MX2101
X_2395_ VALID_IN \U_WINDO _1039_ \U_WINDO VDD VSS MX2101
X_2396_ VALID_IN \U_WINDO _1040_ \U_WINDO VDD VSS MX2101
X_2397_ VALID_IN \U_WINDO _1041_ \U_WINDO VDD VSS MX2101
X_2398_ VALID_IN \U_WINDO _1042_ \U_WINDO VDD VSS MX2101
X_2399_ VALID_IN \U_WINDO _1043_ \U_WINDO VDD VSS MX2101
X_2400_ VALID_IN \U_WINDO _1044_ \U_WINDO VDD VSS MX2101
X_2401_ VALID_IN \U_WINDO _1045_ \U_WINDO VDD VSS MX2101
X_2402_ VALID_IN \U_WINDO _1046_ \U_WINDO VDD VSS MX2101
X_2403_ VALID_IN \U_WINDO _1047_ \U_WINDO VDD VSS MX2101
X_2404_ VALID_IN \U_WINDO _1048_ \U_WINDO VDD VSS MX2101
X_2405_ VALID_IN \U_WINDO _1049_ \U_WINDO VDD VSS MX2101
X_2406_ VALID_IN \U_WINDO _1050_ \U_WINDO VDD VSS MX2101
X_2407_ VALID_IN \U_WINDO _1051_ \U_WINDO VDD VSS MX2101
X_2408_ VALID_IN \U_WINDO _1052_ \U_WINDO VDD VSS MX2101
X_2409_ VALID_IN \U_WINDO _1053_ \U_WINDO VDD VSS MX2101
X_2410_ VALID_IN \U_WINDO _1054_ \U_WINDO VDD VSS MX2101
X_2411_ VALID_IN \U_WINDO _1055_ \U_WINDO VDD VSS MX2101
X_2412_ VALID_IN \U_WINDO _1056_ \U_WINDO VDD VSS MX2101
X_2413_ VALID_IN \U_WINDO _1057_ \U_WINDO VDD VSS MX2101
X_2414_ VALID_IN \U_WINDO _1058_ \U_WINDO VDD VSS MX2101
X_2415_ VALID_IN \U_WINDO _1059_ \U_WINDO VDD VSS MX2101
X_2416_ VALID_IN \U_WINDO _1060_ \U_WINDO VDD VSS MX2101
X_2417_ VALID_IN \U_WINDO _1061_ \U_WINDO VDD VSS MX2101
X_2418_ VALID_IN \U_WINDO _1062_ \U_WINDO VDD VSS MX2101
X_2419_ VALID_IN \U_WINDO _1063_ \U_WINDO VDD VSS MX2101
X_2420_ VALID_IN \U_WINDO _1064_ \U_WINDO VDD VSS MX2101
X_2421_ VALID_IN \U_WINDO _1065_ \U_WINDO VDD VSS MX2101
X_2422_ VALID_IN \U_WINDO _1066_ \U_WINDO VDD VSS MX2101
X_2423_ VALID_IN \U_WINDO _1067_ \U_WINDO VDD VSS MX2101
X_2424_ VALID_IN \U_WINDO _1068_ \U_WINDO VDD VSS MX2101
X_2425_ VALID_IN \U_WINDO _1069_ \U_WINDO VDD VSS MX2101
X_2426_ VALID_IN \U_WINDO _1070_ \U_WINDO VDD VSS MX2101
X_2427_ VALID_IN \U_WINDO _1071_ \U_WINDO VDD VSS MX2101
X_2428_ VALID_IN \U_WINDO _1072_ \U_WINDO VDD VSS MX2101
X_2429_ VALID_IN \U_WINDO _1073_ \U_WINDO VDD VSS MX2101
X_2430_ VALID_IN \U_WINDO _1074_ \U_WINDO VDD VSS MX2101
X_2431_ VALID_IN \U_WINDO _1075_ \U_WINDO VDD VSS MX2101
X_2432_ VALID_IN \U_WINDO _1076_ \U_WINDO VDD VSS MX2101
X_2433_ VALID_IN \U_WINDO _1077_ \U_WINDO VDD VSS MX2101
X_2434_ VALID_IN \U_WINDO _1078_ \U_WINDO VDD VSS MX2101
X_2435_ VALID_IN \U_WINDO _1079_ \U_WINDO VDD VSS MX2101
X_2436_ VALID_IN \U_WINDO _1080_ \U_WINDO VDD VSS MX2101
X_2437_ VALID_IN \U_WINDO _1081_ \U_WINDO VDD VSS MX2101
X_2438_ VALID_IN \U_WINDO _1082_ \U_WINDO VDD VSS MX2101
X_2439_ VALID_IN \U_WINDO _1083_ \U_WINDO VDD VSS MX2101
X_2440_ VALID_IN \U_WINDO _1084_ \U_WINDO VDD VSS MX2101
X_2441_ VALID_IN \U_WINDO _1085_ \U_WINDO VDD VSS MX2101
X_2442_ VALID_IN \U_WINDO _1086_ \U_WINDO VDD VSS MX2101
X_2443_ VALID_IN \U_WINDO _1087_ \U_WINDO VDD VSS MX2101
X_2444_ VALID_IN \U_WINDO _1088_ \U_WINDO VDD VSS MX2101
X_2445_ VALID_IN \U_WINDO _1089_ \U_WINDO VDD VSS MX2101
X_2446_ VALID_IN \U_WINDO _1090_ \U_WINDO VDD VSS MX2101
X_2447_ VALID_IN \U_WINDO _1091_ \U_WINDO VDD VSS MX2101
X_2448_ VALID_IN \U_WINDO _1092_ \U_WINDO VDD VSS MX2101
X_2449_ VALID_IN \U_WINDO _1093_ \U_WINDO VDD VSS MX2101
X_2450_ VALID_IN \U_WINDO _1094_ \U_WINDO VDD VSS MX2101
X_2451_ VALID_IN \U_WINDO _1095_ \U_WINDO VDD VSS MX2101
X_2452_ VALID_IN \U_WINDO _1096_ \U_WINDO VDD VSS MX2101
X_2453_ VALID_IN \U_WINDO _1097_ \U_WINDO VDD VSS MX2101
X_2454_ VALID_IN \U_WINDO _1098_ \U_WINDO VDD VSS MX2101
X_2455_ VALID_IN \U_WINDO _1099_ \U_WINDO VDD VSS MX2101
X_2456_ VALID_IN \U_WINDO _1100_ \U_WINDO VDD VSS MX2101
X_2457_ CLKNET_5_14__LEAF_CLK _1037_ RST_N _1164_ \U_WINDO VSS VDD DFCL11
X_2458_ CLKNET_5_9__LEAF_CLK _1038_ RST_N _1163_ \U_WINDO VSS VDD DFCL11
X_2459_ CLKNET_5_11__LEAF_CLK _1039_ RST_N _1162_ \U_WINDO VSS VDD DFCL11
X_2460_ CLKNET_5_10__LEAF_CLK _1040_ RST_N _1161_ \U_WINDO VSS VDD DFCL11
X_2461_ CLKNET_5_8__LEAF_CLK _1041_ RST_N _1160_ \U_WINDO VSS VDD DFCL11
X_2462_ CLKNET_5_0__LEAF_CLK _1042_ RST_N _1159_ \U_WINDO VSS VDD DFCL11
X_2463_ CLKNET_5_4__LEAF_CLK _1043_ RST_N _1158_ \U_WINDO VSS VDD DFCL11
X_2464_ CLKNET_5_0__LEAF_CLK _1044_ RST_N _1157_ \U_WINDO VSS VDD DFCL11
X_2465_ CLKNET_5_12__LEAF_CLK _1045_ RST_N _1156_ \U_WINDO VSS VDD DFCL11
X_2466_ CLKNET_5_15__LEAF_CLK _1046_ RST_N _1155_ \U_WINDO VSS VDD DFCL11
X_2467_ CLKNET_5_11__LEAF_CLK _1047_ RST_N _1154_ \U_WINDO VSS VDD DFCL11
X_2468_ CLKNET_5_10__LEAF_CLK _1048_ RST_N _1153_ \U_WINDO VSS VDD DFCL11
X_2469_ CLKNET_5_9__LEAF_CLK _1049_ RST_N _1152_ \U_WINDO VSS VDD DFCL11
X_2470_ CLKNET_5_2__LEAF_CLK _1050_ RST_N _1151_ \U_WINDO VSS VDD DFCL11
X_2471_ CLKNET_5_5__LEAF_CLK _1051_ RST_N _1150_ \U_WINDO VSS VDD DFCL11
X_2472_ CLKNET_5_1__LEAF_CLK _1052_ RST_N _1149_ \U_WINDO VSS VDD DFCL11
X_2473_ CLKNET_5_14__LEAF_CLK _1053_ RST_N _1148_ \U_WINDO VSS VDD DFCL11
X_2474_ CLKNET_5_11__LEAF_CLK _1054_ RST_N _1147_ \U_WINDO VSS VDD DFCL11
X_2475_ CLKNET_5_10__LEAF_CLK _1055_ RST_N _1146_ \U_WINDO VSS VDD DFCL11
X_2476_ CLKNET_5_11__LEAF_CLK _1056_ RST_N _1145_ \U_WINDO VSS VDD DFCL11
X_2477_ CLKNET_5_8__LEAF_CLK _1057_ RST_N _1144_ \U_WINDO VSS VDD DFCL11
X_2478_ CLKNET_5_2__LEAF_CLK _1058_ RST_N _1143_ \U_WINDO VSS VDD DFCL11
X_2479_ CLKNET_5_4__LEAF_CLK _1059_ RST_N _1142_ \U_WINDO VSS VDD DFCL11
X_2480_ CLKNET_5_1__LEAF_CLK _1060_ RST_N _1141_ \U_WINDO VSS VDD DFCL11
X_2481_ CLKNET_5_15__LEAF_CLK _1061_ RST_N _1140_ \U_WINDO VSS VDD DFCL11
X_2482_ CLKNET_5_11__LEAF_CLK _1062_ RST_N _1139_ \U_WINDO VSS VDD DFCL11
X_2483_ CLKNET_5_11__LEAF_CLK _1063_ RST_N _1138_ \U_WINDO VSS VDD DFCL11
X_2484_ CLKNET_5_10__LEAF_CLK _1064_ RST_N _1137_ \U_WINDO VSS VDD DFCL11
X_2485_ CLKNET_5_8__LEAF_CLK _1065_ RST_N _1136_ \U_WINDO VSS VDD DFCL11
X_2486_ CLKNET_5_2__LEAF_CLK _1066_ RST_N _1135_ \U_WINDO VSS VDD DFCL11
X_2487_ CLKNET_5_4__LEAF_CLK _1067_ RST_N _1134_ \U_WINDO VSS VDD DFCL11
X_2488_ CLKNET_5_0__LEAF_CLK _1068_ RST_N _1133_ \U_WINDO VSS VDD DFCL11
X_2489_ CLKNET_5_12__LEAF_CLK _1069_ RST_N _1132_ \U_WINDO VSS VDD DFCL11
X_2490_ CLKNET_5_12__LEAF_CLK _1070_ RST_N _1131_ \U_WINDO VSS VDD DFCL11
X_2491_ CLKNET_5_15__LEAF_CLK _1071_ RST_N _1130_ \U_WINDO VSS VDD DFCL11
X_2492_ CLKNET_5_10__LEAF_CLK _1072_ RST_N _1129_ \U_WINDO VSS VDD DFCL11
X_2493_ CLKNET_5_13__LEAF_CLK _1073_ RST_N _1128_ \U_WINDO VSS VDD DFCL11
X_2494_ CLKNET_5_3__LEAF_CLK _1074_ RST_N _1127_ \U_WINDO VSS VDD DFCL11
X_2495_ CLKNET_5_5__LEAF_CLK _1075_ RST_N _1126_ \U_WINDO VSS VDD DFCL11
X_2496_ CLKNET_5_1__LEAF_CLK _1076_ RST_N _1125_ \U_WINDO VSS VDD DFCL11
X_2497_ CLKNET_5_12__LEAF_CLK _1077_ RST_N _1124_ \U_WINDO VSS VDD DFCL11
X_2498_ CLKNET_5_15__LEAF_CLK _1078_ RST_N _1123_ \U_WINDO VSS VDD DFCL11
X_2499_ CLKNET_5_14__LEAF_CLK _1079_ RST_N _1122_ \U_WINDO VSS VDD DFCL11
X_2500_ CLKNET_5_10__LEAF_CLK _1080_ RST_N _1121_ \U_WINDO VSS VDD DFCL11
X_2501_ CLKNET_5_10__LEAF_CLK _1081_ RST_N _1120_ \U_WINDO VSS VDD DFCL11
X_2502_ CLKNET_5_2__LEAF_CLK _1082_ RST_N _1119_ \U_WINDO VSS VDD DFCL11
X_2503_ CLKNET_5_5__LEAF_CLK _1083_ RST_N _1118_ \U_WINDO VSS VDD DFCL11
X_2504_ CLKNET_5_0__LEAF_CLK _1084_ RST_N _1117_ \U_WINDO VSS VDD DFCL11
X_2505_ CLKNET_5_15__LEAF_CLK _1085_ RST_N _1116_ \U_WINDO VSS VDD DFCL11
X_2506_ CLKNET_5_11__LEAF_CLK _1086_ RST_N _1115_ \U_WINDO VSS VDD DFCL11
X_2507_ CLKNET_5_11__LEAF_CLK _1087_ RST_N _1114_ \U_WINDO VSS VDD DFCL11
X_2508_ CLKNET_5_10__LEAF_CLK _1088_ RST_N _1113_ \U_WINDO VSS VDD DFCL11
X_2509_ CLKNET_5_8__LEAF_CLK _1089_ RST_N _1112_ \U_WINDO VSS VDD DFCL11
X_2510_ CLKNET_5_6__LEAF_CLK _1090_ RST_N _1111_ \U_WINDO VSS VDD DFCL11
X_2511_ CLKNET_5_5__LEAF_CLK _1091_ RST_N _1110_ \U_WINDO VSS VDD DFCL11
X_2512_ CLKNET_5_1__LEAF_CLK _1092_ RST_N _1109_ \U_WINDO VSS VDD DFCL11
X_2513_ CLKNET_5_14__LEAF_CLK _1093_ RST_N _1108_ \U_WINDO VSS VDD DFCL11
X_2514_ CLKNET_5_9__LEAF_CLK _1094_ RST_N _1107_ \U_WINDO VSS VDD DFCL11
X_2515_ CLKNET_5_10__LEAF_CLK _1095_ RST_N _1106_ \U_WINDO VSS VDD DFCL11
X_2516_ CLKNET_5_9__LEAF_CLK _1096_ RST_N _1105_ \U_WINDO VSS VDD DFCL11
X_2517_ CLKNET_5_8__LEAF_CLK _1097_ RST_N _1104_ \U_WINDO VSS VDD DFCL11
X_2518_ CLKNET_5_2__LEAF_CLK _1098_ RST_N _1103_ \U_WINDO VSS VDD DFCL11
X_2519_ CLKNET_5_1__LEAF_CLK _1099_ RST_N _1102_ \U_WINDO VSS VDD DFCL11
X_2520_ CLKNET_5_0__LEAF_CLK _1100_ RST_N _1101_ \U_WINDO VSS VDD DFCL11
X_2521_ VALID_IN \U_WINDO _1165_ \U_WINDO VDD VSS MX2101
X_2522_ VALID_IN \U_WINDO _1166_ \U_WINDO VDD VSS MX2101
X_2523_ VALID_IN \U_WINDO _1167_ \U_WINDO VDD VSS MX2101
X_2524_ VALID_IN \U_WINDO _1168_ \U_WINDO VDD VSS MX2101
X_2525_ VALID_IN \U_WINDO _1169_ \U_WINDO VDD VSS MX2101
X_2526_ VALID_IN \U_WINDO _1170_ \U_WINDO VDD VSS MX2101
X_2527_ VALID_IN \U_WINDO _1171_ \U_WINDO VDD VSS MX2101
X_2528_ VALID_IN \U_WINDO _1172_ \U_WINDO VDD VSS MX2101
X_2529_ VALID_IN \U_WINDO _1173_ \U_WINDO VDD VSS MX2101
X_2530_ VALID_IN \U_WINDO _1174_ \U_WINDO VDD VSS MX2101
X_2531_ VALID_IN \U_WINDO _1175_ \U_WINDO VDD VSS MX2101
X_2532_ VALID_IN \U_WINDO _1176_ \U_WINDO VDD VSS MX2101
X_2533_ VALID_IN \U_WINDO _1177_ \U_WINDO VDD VSS MX2101
X_2534_ VALID_IN \U_WINDO _1178_ \U_WINDO VDD VSS MX2101
X_2535_ VALID_IN \U_WINDO _1179_ \U_WINDO VDD VSS MX2101
X_2536_ VALID_IN \U_WINDO _1180_ \U_WINDO VDD VSS MX2101
X_2537_ VALID_IN \U_WINDO _1181_ \U_WINDO VDD VSS MX2101
X_2538_ VALID_IN \U_WINDO _1182_ \U_WINDO VDD VSS MX2101
X_2539_ VALID_IN \U_WINDO _1183_ \U_WINDO VDD VSS MX2101
X_2540_ VALID_IN \U_WINDO _1184_ \U_WINDO VDD VSS MX2101
X_2541_ VALID_IN \U_WINDO _1185_ \U_WINDO VDD VSS MX2101
X_2542_ VALID_IN \U_WINDO _1186_ \U_WINDO VDD VSS MX2101
X_2543_ VALID_IN \U_WINDO _1187_ \U_WINDO VDD VSS MX2101
X_2544_ VALID_IN \U_WINDO _1188_ \U_WINDO VDD VSS MX2101
X_2545_ VALID_IN \U_WINDO _1189_ \U_WINDO VDD VSS MX2101
X_2546_ VALID_IN \U_WINDO _1190_ \U_WINDO VDD VSS MX2101
X_2547_ VALID_IN \U_WINDO _1191_ \U_WINDO VDD VSS MX2101
X_2548_ VALID_IN \U_WINDO _1192_ \U_WINDO VDD VSS MX2101
X_2549_ VALID_IN \U_WINDO _1193_ \U_WINDO VDD VSS MX2101
X_2550_ VALID_IN \U_WINDO _1194_ \U_WINDO VDD VSS MX2101
X_2551_ VALID_IN \U_WINDO _1195_ \U_WINDO VDD VSS MX2101
X_2552_ VALID_IN \U_WINDO _1196_ \U_WINDO VDD VSS MX2101
X_2553_ VALID_IN \U_WINDO _1197_ PIXEL_IN[0] VDD VSS MX2101
X_2554_ VALID_IN \U_WINDO _1198_ PIXEL_IN[1] VDD VSS MX2101
X_2555_ VALID_IN \U_WINDO _1199_ PIXEL_IN[2] VDD VSS MX2101
X_2556_ VALID_IN \U_WINDO _1200_ PIXEL_IN[3] VDD VSS MX2101
X_2557_ VALID_IN \U_WINDO _1201_ PIXEL_IN[4] VDD VSS MX2101
X_2558_ VALID_IN \U_WINDO _1202_ PIXEL_IN[5] VDD VSS MX2101
X_2559_ VALID_IN \U_WINDO _1203_ PIXEL_IN[6] VDD VSS MX2101
X_2560_ VALID_IN \U_WINDO _1204_ PIXEL_IN[7] VDD VSS MX2101
X_2561_ VALID_IN \U_WINDO _1205_ \U_WINDO VDD VSS MX2101
X_2562_ VALID_IN \U_WINDO _1206_ \U_WINDO VDD VSS MX2101
X_2563_ VALID_IN \U_WINDO _1207_ \U_WINDO VDD VSS MX2101
X_2564_ VALID_IN \U_WINDO _1208_ \U_WINDO VDD VSS MX2101
X_2565_ VALID_IN \U_WINDO _1209_ \U_WINDO VDD VSS MX2101
X_2566_ VALID_IN \U_WINDO _1210_ \U_WINDO VDD VSS MX2101
X_2567_ VALID_IN \U_WINDO _1211_ \U_WINDO VDD VSS MX2101
X_2568_ VALID_IN \U_WINDO _1212_ \U_WINDO VDD VSS MX2101
X_2569_ VALID_IN \U_WINDO _1213_ \U_WINDO VDD VSS MX2101
X_2570_ VALID_IN \U_WINDO _1214_ \U_WINDO VDD VSS MX2101
X_2571_ VALID_IN \U_WINDO _1215_ \U_WINDO VDD VSS MX2101
X_2572_ VALID_IN \U_WINDO _1216_ \U_WINDO VDD VSS MX2101
X_2573_ VALID_IN \U_WINDO _1217_ \U_WINDO VDD VSS MX2101
X_2574_ VALID_IN \U_WINDO _1218_ \U_WINDO VDD VSS MX2101
X_2575_ VALID_IN \U_WINDO _1219_ \U_WINDO VDD VSS MX2101
X_2576_ VALID_IN \U_WINDO _1220_ \U_WINDO VDD VSS MX2101
X_2577_ VALID_IN \U_WINDO _1221_ \U_WINDO VDD VSS MX2101
X_2578_ VALID_IN \U_WINDO _1222_ \U_WINDO VDD VSS MX2101
X_2579_ VALID_IN \U_WINDO _1223_ \U_WINDO VDD VSS MX2101
X_2580_ VALID_IN \U_WINDO _1224_ \U_WINDO VDD VSS MX2101
X_2581_ VALID_IN \U_WINDO _1225_ \U_WINDO VDD VSS MX2101
X_2582_ VALID_IN \U_WINDO _1226_ \U_WINDO VDD VSS MX2101
X_2583_ VALID_IN \U_WINDO _1227_ \U_WINDO VDD VSS MX2101
X_2584_ VALID_IN \U_WINDO _1228_ \U_WINDO VDD VSS MX2101
X_2585_ CLKNET_5_25__LEAF_CLK _1165_ RST_N _1292_ \U_WINDO VSS VDD DFCL11
X_2586_ CLKNET_5_24__LEAF_CLK _1166_ RST_N _1291_ \U_WINDO VSS VDD DFCL11
X_2587_ CLKNET_5_30__LEAF_CLK _1167_ RST_N _1290_ \U_WINDO VSS VDD DFCL11
X_2588_ CLKNET_5_26__LEAF_CLK _1168_ RST_N _1289_ \U_WINDO VSS VDD DFCL11
X_2589_ CLKNET_5_24__LEAF_CLK _1169_ RST_N _1288_ \U_WINDO VSS VDD DFCL11
X_2590_ CLKNET_5_14__LEAF_CLK _1170_ RST_N _1287_ \U_WINDO VSS VDD DFCL11
X_2591_ CLKNET_5_16__LEAF_CLK _1171_ RST_N _1286_ \U_WINDO VSS VDD DFCL11
X_2592_ CLKNET_5_1__LEAF_CLK _1172_ RST_N _1285_ \U_WINDO VSS VDD DFCL11
X_2593_ CLKNET_5_28__LEAF_CLK _1173_ RST_N _1284_ \U_WINDO VSS VDD DFCL11
X_2594_ CLKNET_5_25__LEAF_CLK _1174_ RST_N _1283_ \U_WINDO VSS VDD DFCL11
X_2595_ CLKNET_5_31__LEAF_CLK _1175_ RST_N _1282_ \U_WINDO VSS VDD DFCL11
X_2596_ CLKNET_5_25__LEAF_CLK _1176_ RST_N _1281_ \U_WINDO VSS VDD DFCL11
X_2597_ CLKNET_5_24__LEAF_CLK _1177_ RST_N _1280_ \U_WINDO VSS VDD DFCL11
X_2598_ CLKNET_5_26__LEAF_CLK _1178_ RST_N _1279_ \U_WINDO VSS VDD DFCL11
X_2599_ CLKNET_5_21__LEAF_CLK _1179_ RST_N _1278_ \U_WINDO VSS VDD DFCL11
X_2600_ CLKNET_5_3__LEAF_CLK _1180_ RST_N _1277_ \U_WINDO VSS VDD DFCL11
X_2601_ CLKNET_5_25__LEAF_CLK _1181_ RST_N _1276_ \U_WINDO VSS VDD DFCL11
X_2602_ CLKNET_5_24__LEAF_CLK _1182_ RST_N _1275_ \U_WINDO VSS VDD DFCL11
X_2603_ CLKNET_5_28__LEAF_CLK _1183_ RST_N _1274_ \U_WINDO VSS VDD DFCL11
X_2604_ CLKNET_5_24__LEAF_CLK _1184_ RST_N _1273_ \U_WINDO VSS VDD DFCL11
X_2605_ CLKNET_5_24__LEAF_CLK _1185_ RST_N _1272_ \U_WINDO VSS VDD DFCL11
X_2606_ CLKNET_5_15__LEAF_CLK _1186_ RST_N _1271_ \U_WINDO VSS VDD DFCL11
X_2607_ CLKNET_5_20__LEAF_CLK _1187_ RST_N _1270_ \U_WINDO VSS VDD DFCL11
X_2608_ CLKNET_5_2__LEAF_CLK _1188_ RST_N _1269_ \U_WINDO VSS VDD DFCL11
X_2609_ CLKNET_5_30__LEAF_CLK _1189_ RST_N _1268_ \U_WINDO VSS VDD DFCL11
X_2610_ CLKNET_5_26__LEAF_CLK _1190_ RST_N _1267_ \U_WINDO VSS VDD DFCL11
X_2611_ CLKNET_5_28__LEAF_CLK _1191_ RST_N _1266_ \U_WINDO VSS VDD DFCL11
X_2612_ CLKNET_5_24__LEAF_CLK _1192_ RST_N _1265_ \U_WINDO VSS VDD DFCL11
X_2613_ CLKNET_5_24__LEAF_CLK _1193_ RST_N _1264_ \U_WINDO VSS VDD DFCL11
X_2614_ CLKNET_5_15__LEAF_CLK _1194_ RST_N _1263_ \U_WINDO VSS VDD DFCL11
X_2615_ CLKNET_5_20__LEAF_CLK _1195_ RST_N _1262_ \U_WINDO VSS VDD DFCL11
X_2616_ CLKNET_5_3__LEAF_CLK _1196_ RST_N _1261_ \U_WINDO VSS VDD DFCL11
X_2617_ CLKNET_5_31__LEAF_CLK _1197_ RST_N _1260_ \U_WINDO VSS VDD DFCL11
X_2618_ CLKNET_5_30__LEAF_CLK _1198_ RST_N _1259_ \U_WINDO VSS VDD DFCL11
X_2619_ CLKNET_5_29__LEAF_CLK _1199_ RST_N _1258_ \U_WINDO VSS VDD DFCL11
X_2620_ CLKNET_5_25__LEAF_CLK _1200_ RST_N _1257_ \U_WINDO VSS VDD DFCL11
X_2621_ CLKNET_5_25__LEAF_CLK _1201_ RST_N _1256_ \U_WINDO VSS VDD DFCL11
X_2622_ CLKNET_5_27__LEAF_CLK _1202_ RST_N _1255_ \U_WINDO VSS VDD DFCL11
X_2623_ CLKNET_5_21__LEAF_CLK _1203_ RST_N _1254_ \U_WINDO VSS VDD DFCL11
X_2624_ CLKNET_5_18__LEAF_CLK _1204_ RST_N _1253_ \U_WINDO VSS VDD DFCL11
X_2625_ CLKNET_5_31__LEAF_CLK _1205_ RST_N _1252_ \U_WINDO VSS VDD DFCL11
X_2626_ CLKNET_5_30__LEAF_CLK _1206_ RST_N _1251_ \U_WINDO VSS VDD DFCL11
X_2627_ CLKNET_5_28__LEAF_CLK _1207_ RST_N _1250_ \U_WINDO VSS VDD DFCL11
X_2628_ CLKNET_5_25__LEAF_CLK _1208_ RST_N _1249_ \U_WINDO VSS VDD DFCL11
X_2629_ CLKNET_5_27__LEAF_CLK _1209_ RST_N _1248_ \U_WINDO VSS VDD DFCL11
X_2630_ CLKNET_5_27__LEAF_CLK _1210_ RST_N _1247_ \U_WINDO VSS VDD DFCL11
X_2631_ CLKNET_5_21__LEAF_CLK _1211_ RST_N _1246_ \U_WINDO VSS VDD DFCL11
X_2632_ CLKNET_5_3__LEAF_CLK _1212_ RST_N _1245_ \U_WINDO VSS VDD DFCL11
X_2633_ CLKNET_5_31__LEAF_CLK _1213_ RST_N _1244_ \U_WINDO VSS VDD DFCL11
X_2634_ CLKNET_5_24__LEAF_CLK _1214_ RST_N _1243_ \U_WINDO VSS VDD DFCL11
X_2635_ CLKNET_5_31__LEAF_CLK _1215_ RST_N _1242_ \U_WINDO VSS VDD DFCL11
X_2636_ CLKNET_5_26__LEAF_CLK _1216_ RST_N _1241_ \U_WINDO VSS VDD DFCL11
X_2637_ CLKNET_5_27__LEAF_CLK _1217_ RST_N _1240_ \U_WINDO VSS VDD DFCL11
X_2638_ CLKNET_5_26__LEAF_CLK _1218_ RST_N _1239_ \U_WINDO VSS VDD DFCL11
X_2639_ CLKNET_5_20__LEAF_CLK _1219_ RST_N _1238_ \U_WINDO VSS VDD DFCL11
X_2640_ CLKNET_5_3__LEAF_CLK _1220_ RST_N _1237_ \U_WINDO VSS VDD DFCL11
X_2641_ CLKNET_5_26__LEAF_CLK _1221_ RST_N _1236_ \U_WINDO VSS VDD DFCL11
X_2642_ CLKNET_5_13__LEAF_CLK _1222_ RST_N _1235_ \U_WINDO VSS VDD DFCL11
X_2643_ CLKNET_5_30__LEAF_CLK _1223_ RST_N _1234_ \U_WINDO VSS VDD DFCL11
X_2644_ CLKNET_5_13__LEAF_CLK _1224_ RST_N _1233_ \U_WINDO VSS VDD DFCL11
X_2645_ CLKNET_5_13__LEAF_CLK _1225_ RST_N _1232_ \U_WINDO VSS VDD DFCL11
X_2646_ CLKNET_5_14__LEAF_CLK _1226_ RST_N _1231_ \U_WINDO VSS VDD DFCL11
X_2647_ CLKNET_5_5__LEAF_CLK _1227_ RST_N _1230_ \U_WINDO VSS VDD DFCL11
X_2648_ CLKNET_5_0__LEAF_CLK _1228_ RST_N _1229_ \U_WINDO VSS VDD DFCL11
XCLKBUF_0_CLK CLK CLKNET_0_CLK VDD VSS CDRI01
XCLKBUF_2_0_0_CLK CLKNET_0_CLK CLKNET_2_0_0_CLK VDD VSS CDRI01
XCLKBUF_2_1_0_CLK CLKNET_0_CLK CLKNET_2_1_0_CLK VDD VSS CDRI01
XCLKBUF_2_2_0_CLK CLKNET_0_CLK CLKNET_2_2_0_CLK VDD VSS CDRI01
XCLKBUF_2_3_0_CLK CLKNET_0_CLK CLKNET_2_3_0_CLK VDD VSS CDRI01
XCLKBUF_4_0_0_CLK CLKNET_2_0_0_CLK CLKNET_4_0_0_CLK VDD VSS CDRI01
XCLKBUF_4_1_0_CLK CLKNET_2_0_0_CLK CLKNET_4_1_0_CLK VDD VSS CDRI01
XCLKBUF_4_2_0_CLK CLKNET_2_0_0_CLK CLKNET_4_2_0_CLK VDD VSS CDRI01
XCLKBUF_4_3_0_CLK CLKNET_2_0_0_CLK CLKNET_4_3_0_CLK VDD VSS CDRI01
XCLKBUF_4_4_0_CLK CLKNET_2_1_0_CLK CLKNET_4_4_0_CLK VDD VSS CDRI01
XCLKBUF_4_5_0_CLK CLKNET_2_1_0_CLK CLKNET_4_5_0_CLK VDD VSS CDRI01
XCLKBUF_4_6_0_CLK CLKNET_2_1_0_CLK CLKNET_4_6_0_CLK VDD VSS CDRI01
XCLKBUF_4_7_0_CLK CLKNET_2_1_0_CLK CLKNET_4_7_0_CLK VDD VSS CDRI01
XCLKBUF_4_8_0_CLK CLKNET_2_2_0_CLK CLKNET_4_8_0_CLK VDD VSS CDRI01
XCLKBUF_4_9_0_CLK CLKNET_2_2_0_CLK CLKNET_4_9_0_CLK VDD VSS CDRI01
XCLKBUF_4_10_0_CLK CLKNET_2_2_0_CLK CLKNET_4_10_0_CLK VDD VSS CDRI01
XCLKBUF_4_11_0_CLK CLKNET_2_2_0_CLK CLKNET_4_11_0_CLK VDD VSS CDRI01
XCLKBUF_4_12_0_CLK CLKNET_2_3_0_CLK CLKNET_4_12_0_CLK VDD VSS CDRI01
XCLKBUF_4_13_0_CLK CLKNET_2_3_0_CLK CLKNET_4_13_0_CLK VDD VSS CDRI01
XCLKBUF_4_14_0_CLK CLKNET_2_3_0_CLK CLKNET_4_14_0_CLK VDD VSS CDRI01
XCLKBUF_4_15_0_CLK CLKNET_2_3_0_CLK CLKNET_4_15_0_CLK VDD VSS CDRI01
XCLKBUF_5_0__F_CLK CLKNET_4_0_0_CLK CLKNET_5_0__LEAF_CLK VDD VSS CDRI01
XCLKBUF_5_1__F_CLK CLKNET_4_0_0_CLK CLKNET_5_1__LEAF_CLK VDD VSS CDRI01
XCLKBUF_5_2__F_CLK CLKNET_4_1_0_CLK CLKNET_5_2__LEAF_CLK VDD VSS CDRI01
XCLKBUF_5_3__F_CLK CLKNET_4_1_0_CLK CLKNET_5_3__LEAF_CLK VDD VSS CDRI01
XCLKBUF_5_4__F_CLK CLKNET_4_2_0_CLK CLKNET_5_4__LEAF_CLK VDD VSS CDRI01
XCLKBUF_5_5__F_CLK CLKNET_4_2_0_CLK CLKNET_5_5__LEAF_CLK VDD VSS CDRI01
XCLKBUF_5_6__F_CLK CLKNET_4_3_0_CLK CLKNET_5_6__LEAF_CLK VDD VSS CDRI01
XCLKBUF_5_7__F_CLK CLKNET_4_3_0_CLK CLKNET_5_7__LEAF_CLK VDD VSS CDRI01
XCLKBUF_5_8__F_CLK CLKNET_4_4_0_CLK CLKNET_5_8__LEAF_CLK VDD VSS CDRI01
XCLKBUF_5_9__F_CLK CLKNET_4_4_0_CLK CLKNET_5_9__LEAF_CLK VDD VSS CDRI01
XCLKBUF_5_10__F_CLK CLKNET_4_5_0_CLK CLKNET_5_10__LEAF_CLK VDD VSS CDRI01
XCLKBUF_5_11__F_CLK CLKNET_4_5_0_CLK CLKNET_5_11__LEAF_CLK VDD VSS CDRI01
XCLKBUF_5_12__F_CLK CLKNET_4_6_0_CLK CLKNET_5_12__LEAF_CLK VDD VSS CDRI01
XCLKBUF_5_13__F_CLK CLKNET_4_6_0_CLK CLKNET_5_13__LEAF_CLK VDD VSS CDRI01
XCLKBUF_5_14__F_CLK CLKNET_4_7_0_CLK CLKNET_5_14__LEAF_CLK VDD VSS CDRI01
XCLKBUF_5_15__F_CLK CLKNET_4_7_0_CLK CLKNET_5_15__LEAF_CLK VDD VSS CDRI01
XCLKBUF_5_16__F_CLK CLKNET_4_8_0_CLK CLKNET_5_16__LEAF_CLK VDD VSS CDRI01
XCLKBUF_5_17__F_CLK CLKNET_4_8_0_CLK CLKNET_5_17__LEAF_CLK VDD VSS CDRI01
XCLKBUF_5_18__F_CLK CLKNET_4_9_0_CLK CLKNET_5_18__LEAF_CLK VDD VSS CDRI01
XCLKBUF_5_19__F_CLK CLKNET_4_9_0_CLK CLKNET_5_19__LEAF_CLK VDD VSS CDRI01
XCLKBUF_5_20__F_CLK CLKNET_4_10_0_CLK CLKNET_5_20__LEAF_CLK VDD VSS CDRI01
XCLKBUF_5_21__F_CLK CLKNET_4_10_0_CLK CLKNET_5_21__LEAF_CLK VDD VSS CDRI01
XCLKBUF_5_22__F_CLK CLKNET_4_11_0_CLK CLKNET_5_22__LEAF_CLK VDD VSS CDRI01
XCLKBUF_5_23__F_CLK CLKNET_4_11_0_CLK CLKNET_5_23__LEAF_CLK VDD VSS CDRI01
XCLKBUF_5_24__F_CLK CLKNET_4_12_0_CLK CLKNET_5_24__LEAF_CLK VDD VSS CDRI01
XCLKBUF_5_25__F_CLK CLKNET_4_12_0_CLK CLKNET_5_25__LEAF_CLK VDD VSS CDRI01
XCLKBUF_5_26__F_CLK CLKNET_4_13_0_CLK CLKNET_5_26__LEAF_CLK VDD VSS CDRI01
XCLKBUF_5_27__F_CLK CLKNET_4_13_0_CLK CLKNET_5_27__LEAF_CLK VDD VSS CDRI01
XCLKBUF_5_28__F_CLK CLKNET_4_14_0_CLK CLKNET_5_28__LEAF_CLK VDD VSS CDRI01
XCLKBUF_5_29__F_CLK CLKNET_4_14_0_CLK CLKNET_5_29__LEAF_CLK VDD VSS CDRI01
XCLKBUF_5_30__F_CLK CLKNET_4_15_0_CLK CLKNET_5_30__LEAF_CLK VDD VSS CDRI01
XCLKBUF_5_31__F_CLK CLKNET_4_15_0_CLK CLKNET_5_31__LEAF_CLK VDD VSS CDRI01
XCLKLOAD0 CLKNET_5_1__LEAF_CLK VDD VSS INVR01
XCLKLOAD1 CLKNET_5_3__LEAF_CLK VDD VSS INVR01
XCLKLOAD2 CLKNET_5_5__LEAF_CLK VDD VSS INVR01
XCLKLOAD3 CLKNET_5_7__LEAF_CLK VDD VSS INVR01
XCLKLOAD4 CLKNET_5_9__LEAF_CLK VDD VSS INVR01
XCLKLOAD5 CLKNET_5_11__LEAF_CLK VDD VSS INVR01
XCLKLOAD6 CLKNET_5_13__LEAF_CLK VDD VSS INVR01
XCLKLOAD7 CLKNET_5_17__LEAF_CLK VDD VSS INVR01
XCLKLOAD8 CLKNET_5_19__LEAF_CLK VDD VSS INVR01
XCLKLOAD9 CLKNET_5_21__LEAF_CLK VDD VSS INVR01
XCLKLOAD10 CLKNET_5_23__LEAF_CLK VDD VSS INVR01
XCLKLOAD11 CLKNET_5_25__LEAF_CLK VDD VSS INVR01
XCLKLOAD12 CLKNET_5_27__LEAF_CLK VDD VSS INVR01
XCLKLOAD13 CLKNET_5_29__LEAF_CLK VDD VSS INVR01

.ENDS FIR2D_TOP
